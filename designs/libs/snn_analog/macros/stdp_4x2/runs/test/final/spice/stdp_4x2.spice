* NGSPICE file created from stdp_4x2.ext - technology: gf180mcuD

* Black-box entry subcircuit for stdp abstract view
.subckt stdp avdd avss nvpost vpost vpre vb_idep vb_itd vb_itp vb_pot nvpre Iout vw
.ends

* Black-box entry subcircuit for Current_limit abstract view
.subckt Current_limit i_SUM ifwd avdd avss
.ends

.subckt stdp_4x2 A B avdd avss ifwd1 ifwd2 nvpost1 nvpost2 nvpre1 nvpre2 nvpre3 nvpre4
+ vpost1 vpost2 vpre1 vpre2 vpre3 vpre4 vw11 vw42
Xx1 avdd avss nvpost1 vpost1 vpre1 B A B A nvpre1 x4/Iout vw11 stdp
Xx2 avdd avss nvpost1 vpost1 vpre2 B A B A nvpre2 x4/Iout x2/vw stdp
Xx3 avdd avss nvpost1 vpost1 vpre3 B A B A nvpre3 x4/Iout x3/vw stdp
Xx4 avdd avss nvpost1 vpost1 vpre4 B A B A nvpre4 x4/Iout x4/vw stdp
Xx5 avdd avss nvpost2 vpost2 vpre1 B A B A nvpre1 x8/Iout x5/vw stdp
Xx6 avdd avss nvpost2 vpost2 vpre2 B A B A nvpre2 x8/Iout x6/vw stdp
Xx7 avdd avss nvpost2 vpost2 vpre3 B A B A nvpre3 x8/Iout x7/vw stdp
Xx8 avdd avss nvpost2 vpost2 vpre4 B A B A nvpre4 x8/Iout vw42 stdp
Xx9 x4/Iout ifwd1 avdd avss Current_limit
Xx10 x8/Iout ifwd2 avdd avss Current_limit
.ends
