* NGSPICE file created from layer_input.ext - technology: gf180mcuD

* Black-box entry subcircuit for neurona_lvs abstract view
.subckt neurona_lvs vss vdd Iin spike_neg spike
.ends

.subckt layer_input Iext1 Iext2 Iext3 Iext4 nvout_1 nvout_2 nvout_3 nvout_4 vdd vout_1
+ vout_2 vout_3 vout_4 vss
Xx1 vss vdd Iext1 nvout_1 vout_1 neurona_lvs
Xx2 vss vdd Iext2 nvout_2 vout_2 neurona_lvs
Xx3 vss vdd Iext3 nvout_3 vout_3 neurona_lvs
Xx4 vss vdd Iext4 nvout_4 vout_4 neurona_lvs
.ends
