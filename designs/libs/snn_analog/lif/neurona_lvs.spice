* NGSPICE file created from neurona_lvs.ext - technology: gf180mcuD

.subckt Unnamed_350e5573 a_n5000_n519# a_n5120_n311# a_n5330_n683# a_5000_n311#
X0 a_5000_n311# a_n5000_n519# a_n5120_n311# a_n5330_n683# nfet_03v3 ad=1.38p pd=5.8u as=1.38p ps=5.8u w=2.3u l=50u
C0 a_5000_n311# a_n5120_n311# 4.41467f
C1 a_5000_n311# a_n5000_n519# 0.22856f
C2 a_n5000_n519# a_n5120_n311# 1.8049f
C3 a_5000_n311# a_n5330_n683# 5.37377f
C4 a_n5120_n311# a_n5330_n683# 1.24677f
C5 a_n5000_n519# a_n5330_n683# 21.8141f
.ends

.subckt Unnamed_02571b72 a_64_n131# w_n450_n560# a_n64_n339# a_n184_n131# VSUBS
X0 a_64_n131# a_n64_n339# a_n184_n131# w_n450_n560# pfet_03v3 ad=0.3p pd=2.2u as=0.3p ps=2.2u w=0.5u l=0.64u
C0 a_n64_n339# w_n450_n560# 0.46029f
C1 w_n450_n560# a_n184_n131# 0.22492f
C2 a_n64_n339# a_64_n131# 0.01761f
C3 a_64_n131# a_n184_n131# 0.33132f
C4 w_n450_n560# a_64_n131# 0.48547f
C5 a_n64_n339# a_n184_n131# 0.04083f
C6 a_64_n131# VSUBS 0.04567f
C7 a_n184_n131# VSUBS 0.04433f
C8 a_n64_n339# VSUBS 0.0526f
C9 w_n450_n560# VSUBS 3.77582f
.ends

.subckt Unnamed_2af03fd8 a_64_n131# a_n394_n504# a_n64_n339# a_n184_n131#
X0 a_64_n131# a_n64_n339# a_n184_n131# a_n394_n504# nfet_03v3 ad=0.3p pd=2.2u as=0.3p ps=2.2u w=0.5u l=0.64u
C0 a_n184_n131# a_n64_n339# 0.04083f
C1 a_n64_n339# a_64_n131# 0.01761f
C2 a_n184_n131# a_64_n131# 0.33132f
C3 a_64_n131# a_n394_n504# 0.53111f
C4 a_n184_n131# a_n394_n504# 0.26925f
C5 a_n64_n339# a_n394_n504# 0.51289f
.ends

.subckt neurona_lvs spike Vdd Vss
XUnnamed_350e5573_0 Vss Vss Vss Vss Unnamed_350e5573
XUnnamed_02571b72_0 spike Vdd Unnamed_2af03fd8_2/a_64_n131# Vdd Vss Unnamed_02571b72
XUnnamed_02571b72_1 Vss Vdd Unnamed_2af03fd8_2/a_64_n131# Vdd Vss Unnamed_02571b72
XUnnamed_02571b72_2 Unnamed_2af03fd8_2/a_64_n131# Vdd Unnamed_2af03fd8_2/a_n64_n339#
+ Vdd Vss Unnamed_02571b72
XUnnamed_2af03fd8_0 spike Vss Unnamed_2af03fd8_2/a_64_n131# Vss Unnamed_2af03fd8
XUnnamed_2af03fd8_1 Vss Vss Unnamed_2af03fd8_2/a_64_n131# Vss Unnamed_2af03fd8
XUnnamed_2af03fd8_2 Unnamed_2af03fd8_2/a_64_n131# Vss Unnamed_2af03fd8_2/a_n64_n339#
+ Vss Unnamed_2af03fd8
R0 Vss.n572 Vss.n25 18200
R1 Vss.n571 Vss.n26 18200
R2 Vss.n573 Vss.n572 14238.8
R3 Vss.n572 Vss.n571 4468.75
R4 Vss.n571 Vss.n570 4062.5
R5 Vss.n574 Vss.n573 229.434
R6 Vss.n563 Vss.n38 144.525
R7 Vss.n452 Vss.n410 144.525
R8 Vss.n443 Vss.n442 144.525
R9 Vss.n432 Vss.n430 144.525
R10 Vss.n592 Vss.n5 140.912
R11 Vss.n591 Vss.n8 140.912
R12 Vss.n412 Vss.n26 139.106
R13 Vss.n439 Vss.n25 131.88
R14 Vss.n562 Vss.n41 130.072
R15 Vss.n458 Vss.n390 130.072
R16 Vss.n431 Vss.n57 128.267
R17 Vss.n542 Vss.n57 122.847
R18 Vss.n541 Vss.n22 122.847
R19 Vss.n458 Vss.n400 121.04
R20 Vss.n411 Vss.n5 110.201
R21 Vss.n442 Vss.n441 102.975
R22 Vss.n262 Vss.n252 94.2375
R23 Vss.n262 Vss.n246 94.2375
R24 Vss.n270 Vss.n246 94.2375
R25 Vss.n270 Vss.n240 94.2375
R26 Vss.n278 Vss.n240 94.2375
R27 Vss.n278 Vss.n234 94.2375
R28 Vss.n286 Vss.n234 94.2375
R29 Vss.n286 Vss.n228 94.2375
R30 Vss.n294 Vss.n228 94.2375
R31 Vss.n294 Vss.n222 94.2375
R32 Vss.n302 Vss.n222 94.2375
R33 Vss.n302 Vss.n216 94.2375
R34 Vss.n313 Vss.n216 94.2375
R35 Vss.n313 Vss.n210 94.2375
R36 Vss.n321 Vss.n210 94.2375
R37 Vss.n321 Vss.n82 94.2375
R38 Vss.n524 Vss.n82 94.2375
R39 Vss.n524 Vss.n523 94.2375
R40 Vss.n523 Vss.n522 94.2375
R41 Vss.n522 Vss.n86 94.2375
R42 Vss.n516 Vss.n86 94.2375
R43 Vss.n516 Vss.n515 94.2375
R44 Vss.n515 Vss.n514 94.2375
R45 Vss.n514 Vss.n97 94.2375
R46 Vss.n508 Vss.n97 94.2375
R47 Vss.n508 Vss.n507 94.2375
R48 Vss.n507 Vss.n506 94.2375
R49 Vss.n506 Vss.n107 94.2375
R50 Vss.n500 Vss.n107 94.2375
R51 Vss.n500 Vss.n499 94.2375
R52 Vss.n499 Vss.n498 94.2375
R53 Vss.n498 Vss.n117 94.2375
R54 Vss.n492 Vss.n117 94.2375
R55 Vss.n492 Vss.n491 94.2375
R56 Vss.n491 Vss.n490 94.2375
R57 Vss.n490 Vss.n127 94.2375
R58 Vss.n484 Vss.n127 94.2375
R59 Vss.n484 Vss.n483 94.2375
R60 Vss.n483 Vss.n482 94.2375
R61 Vss.n482 Vss.n137 94.2375
R62 Vss.n476 Vss.n137 94.2375
R63 Vss.n476 Vss.n475 94.2375
R64 Vss.n475 Vss.n474 94.2375
R65 Vss.n474 Vss.n147 94.2375
R66 Vss.n147 Vss.n27 94.2375
R67 Vss.n38 Vss.n29 92.135
R68 Vss.n23 Vss.n21 84.0977
R69 Vss.n575 Vss.n21 84.0977
R70 Vss.n256 Vss.n253 84.0977
R71 Vss.n570 Vss.n27 74.2122
R72 Vss.n58 Vss.n24 69.0283
R73 Vss.n56 Vss.n24 69.0283
R74 Vss.n543 Vss.n55 69.0283
R75 Vss.n67 Vss.n55 69.0283
R76 Vss.n399 Vss.n398 69.0283
R77 Vss.n399 Vss.n43 69.0283
R78 Vss.n561 Vss.n42 69.0283
R79 Vss.n42 Vss.n40 69.0283
R80 Vss.n440 Vss.n3 69.0283
R81 Vss.n440 Vss.n50 69.0283
R82 Vss.n6 Vss.n4 69.0283
R83 Vss.n593 Vss.n4 69.0283
R84 Vss.n256 Vss.n255 52.7258
R85 Vss.n569 Vss.n29 52.3907
R86 Vss.n441 Vss.n439 41.5514
R87 Vss.n412 Vss.n411 34.3251
R88 Vss.n570 Vss.n569 30.712
R89 Vss.n410 Vss.n400 23.4858
R90 Vss.n542 Vss.n541 21.6792
R91 Vss.n574 Vss.n22 21.6792
R92 Vss.n596 Vss.n595 16.6691
R93 Vss.n432 Vss.n431 16.2595
R94 Vss.n543 Vss.n56 15.5561
R95 Vss.n67 Vss.n58 15.5561
R96 Vss.n561 Vss.n43 15.5561
R97 Vss.n398 Vss.n40 15.5561
R98 Vss.n263 Vss.n251 15.5561
R99 Vss.n263 Vss.n247 15.5561
R100 Vss.n269 Vss.n247 15.5561
R101 Vss.n269 Vss.n239 15.5561
R102 Vss.n279 Vss.n239 15.5561
R103 Vss.n279 Vss.n235 15.5561
R104 Vss.n285 Vss.n235 15.5561
R105 Vss.n285 Vss.n227 15.5561
R106 Vss.n295 Vss.n227 15.5561
R107 Vss.n295 Vss.n223 15.5561
R108 Vss.n301 Vss.n223 15.5561
R109 Vss.n301 Vss.n215 15.5561
R110 Vss.n314 Vss.n215 15.5561
R111 Vss.n314 Vss.n211 15.5561
R112 Vss.n320 Vss.n211 15.5561
R113 Vss.n320 Vss.n80 15.5561
R114 Vss.n525 Vss.n80 15.5561
R115 Vss.n525 Vss.n81 15.5561
R116 Vss.n521 Vss.n81 15.5561
R117 Vss.n521 Vss.n87 15.5561
R118 Vss.n517 Vss.n87 15.5561
R119 Vss.n517 Vss.n93 15.5561
R120 Vss.n513 Vss.n93 15.5561
R121 Vss.n513 Vss.n98 15.5561
R122 Vss.n509 Vss.n98 15.5561
R123 Vss.n509 Vss.n103 15.5561
R124 Vss.n505 Vss.n103 15.5561
R125 Vss.n505 Vss.n108 15.5561
R126 Vss.n501 Vss.n108 15.5561
R127 Vss.n501 Vss.n113 15.5561
R128 Vss.n497 Vss.n113 15.5561
R129 Vss.n497 Vss.n118 15.5561
R130 Vss.n493 Vss.n118 15.5561
R131 Vss.n493 Vss.n123 15.5561
R132 Vss.n489 Vss.n123 15.5561
R133 Vss.n489 Vss.n128 15.5561
R134 Vss.n485 Vss.n128 15.5561
R135 Vss.n485 Vss.n133 15.5561
R136 Vss.n481 Vss.n133 15.5561
R137 Vss.n481 Vss.n138 15.5561
R138 Vss.n477 Vss.n138 15.5561
R139 Vss.n477 Vss.n143 15.5561
R140 Vss.n473 Vss.n143 15.5561
R141 Vss.n473 Vss.n148 15.5561
R142 Vss.n148 Vss.n30 15.5561
R143 Vss.n568 Vss.n30 15.5561
R144 Vss.n568 Vss.n31 15.5561
R145 Vss.n564 Vss.n31 15.5561
R146 Vss.n564 Vss.n37 15.5561
R147 Vss.n457 Vss.n37 15.5561
R148 Vss.n457 Vss.n401 15.5561
R149 Vss.n453 Vss.n401 15.5561
R150 Vss.n453 Vss.n409 15.5561
R151 Vss.n409 Vss.n9 15.5561
R152 Vss.n590 Vss.n9 15.5561
R153 Vss.n590 Vss.n10 15.5561
R154 Vss.n12 Vss.n10 15.5561
R155 Vss.n438 Vss.n12 15.5561
R156 Vss.n438 Vss.n15 15.5561
R157 Vss.n16 Vss.n15 15.5561
R158 Vss.n17 Vss.n16 15.5561
R159 Vss.n20 Vss.n17 15.5561
R160 Vss.n575 Vss.n20 15.5561
R161 Vss.n261 Vss.n253 15.5561
R162 Vss.n261 Vss.n245 15.5561
R163 Vss.n271 Vss.n245 15.5561
R164 Vss.n271 Vss.n241 15.5561
R165 Vss.n277 Vss.n241 15.5561
R166 Vss.n277 Vss.n233 15.5561
R167 Vss.n287 Vss.n233 15.5561
R168 Vss.n287 Vss.n229 15.5561
R169 Vss.n293 Vss.n229 15.5561
R170 Vss.n293 Vss.n221 15.5561
R171 Vss.n303 Vss.n221 15.5561
R172 Vss.n303 Vss.n217 15.5561
R173 Vss.n312 Vss.n217 15.5561
R174 Vss.n312 Vss.n209 15.5561
R175 Vss.n322 Vss.n209 15.5561
R176 Vss.n323 Vss.n322 15.5561
R177 Vss.n323 Vss.n83 15.5561
R178 Vss.n84 Vss.n83 15.5561
R179 Vss.n85 Vss.n84 15.5561
R180 Vss.n329 Vss.n85 15.5561
R181 Vss.n329 Vss.n94 15.5561
R182 Vss.n95 Vss.n94 15.5561
R183 Vss.n96 Vss.n95 15.5561
R184 Vss.n332 Vss.n96 15.5561
R185 Vss.n332 Vss.n104 15.5561
R186 Vss.n105 Vss.n104 15.5561
R187 Vss.n106 Vss.n105 15.5561
R188 Vss.n347 Vss.n106 15.5561
R189 Vss.n347 Vss.n114 15.5561
R190 Vss.n115 Vss.n114 15.5561
R191 Vss.n116 Vss.n115 15.5561
R192 Vss.n350 Vss.n116 15.5561
R193 Vss.n350 Vss.n124 15.5561
R194 Vss.n125 Vss.n124 15.5561
R195 Vss.n126 Vss.n125 15.5561
R196 Vss.n366 Vss.n126 15.5561
R197 Vss.n366 Vss.n134 15.5561
R198 Vss.n135 Vss.n134 15.5561
R199 Vss.n136 Vss.n135 15.5561
R200 Vss.n369 Vss.n136 15.5561
R201 Vss.n369 Vss.n144 15.5561
R202 Vss.n145 Vss.n144 15.5561
R203 Vss.n146 Vss.n145 15.5561
R204 Vss.n468 Vss.n146 15.5561
R205 Vss.n468 Vss.n467 15.5561
R206 Vss.n467 Vss.n28 15.5561
R207 Vss.n463 Vss.n28 15.5561
R208 Vss.n463 Vss.n39 15.5561
R209 Vss.n460 Vss.n39 15.5561
R210 Vss.n460 Vss.n459 15.5561
R211 Vss.n459 Vss.n389 15.5561
R212 Vss.n451 Vss.n389 15.5561
R213 Vss.n451 Vss.n413 15.5561
R214 Vss.n447 Vss.n413 15.5561
R215 Vss.n447 Vss.n7 15.5561
R216 Vss.n444 Vss.n7 15.5561
R217 Vss.n444 Vss.n423 15.5561
R218 Vss.n437 Vss.n423 15.5561
R219 Vss.n437 Vss.n424 15.5561
R220 Vss.n433 Vss.n424 15.5561
R221 Vss.n433 Vss.n68 15.5561
R222 Vss.n540 Vss.n68 15.5561
R223 Vss.n540 Vss.n23 15.5561
R224 Vss.n50 Vss.n6 15.5561
R225 Vss.n563 Vss.n562 14.453
R226 Vss.n390 Vss.n41 14.453
R227 Vss.n430 Vss.n25 12.6464
R228 Vss.n470 Vss.n154 12.5005
R229 Vss.n378 Vss.n149 12.5005
R230 Vss.n380 Vss.n379 12.5005
R231 Vss.n377 Vss.n141 12.5005
R232 Vss.n376 Vss.n140 12.5005
R233 Vss.n375 Vss.n139 12.5005
R234 Vss.n374 Vss.n373 12.5005
R235 Vss.n157 Vss.n131 12.5005
R236 Vss.n360 Vss.n130 12.5005
R237 Vss.n361 Vss.n129 12.5005
R238 Vss.n363 Vss.n362 12.5005
R239 Vss.n359 Vss.n121 12.5005
R240 Vss.n358 Vss.n120 12.5005
R241 Vss.n356 Vss.n119 12.5005
R242 Vss.n355 Vss.n354 12.5005
R243 Vss.n164 Vss.n111 12.5005
R244 Vss.n341 Vss.n110 12.5005
R245 Vss.n342 Vss.n109 12.5005
R246 Vss.n344 Vss.n343 12.5005
R247 Vss.n340 Vss.n101 12.5005
R248 Vss.n339 Vss.n100 12.5005
R249 Vss.n338 Vss.n99 12.5005
R250 Vss.n337 Vss.n336 12.5005
R251 Vss.n172 Vss.n91 12.5005
R252 Vss.n171 Vss.n90 12.5005
R253 Vss.n170 Vss.n88 12.5005
R254 Vss.n326 Vss.n76 12.5005
R255 Vss.n528 Vss.n76 11.7031
R256 Vss.n154 Vss.n153 11.545
R257 Vss.n534 Vss.n533 7.89186
R258 Vss.n533 Vss.n73 7.75378
R259 Vss.n535 Vss.n534 7.73533
R260 Vss.n61 Vss.n19 6.395
R261 Vss.n170 Vss.n76 5.61588
R262 Vss.n171 Vss.n170 5.61588
R263 Vss.n172 Vss.n171 5.61588
R264 Vss.n337 Vss.n172 5.61588
R265 Vss.n338 Vss.n337 5.61588
R266 Vss.n339 Vss.n338 5.61588
R267 Vss.n340 Vss.n339 5.61588
R268 Vss.n343 Vss.n340 5.61588
R269 Vss.n343 Vss.n342 5.61588
R270 Vss.n342 Vss.n341 5.61588
R271 Vss.n341 Vss.n164 5.61588
R272 Vss.n355 Vss.n164 5.61588
R273 Vss.n356 Vss.n355 5.61588
R274 Vss.n359 Vss.n358 5.61588
R275 Vss.n362 Vss.n359 5.61588
R276 Vss.n362 Vss.n361 5.61588
R277 Vss.n361 Vss.n360 5.61588
R278 Vss.n360 Vss.n157 5.61588
R279 Vss.n374 Vss.n157 5.61588
R280 Vss.n375 Vss.n374 5.61588
R281 Vss.n376 Vss.n375 5.61588
R282 Vss.n377 Vss.n376 5.61588
R283 Vss.n379 Vss.n377 5.61588
R284 Vss.n379 Vss.n378 5.61588
R285 Vss.n378 Vss.n154 5.61588
R286 Vss Vss.n75 5.4833
R287 Vss.n452 Vss.n26 5.42018
R288 Vss.n258 Vss.n257 5.35452
R289 Vss.n257 Vss.n249 5.35452
R290 Vss.n59 Vss.n52 5.20101
R291 Vss.n395 Vss.n394 5.20101
R292 Vss.n467 Vss.n466 5.2005
R293 Vss.n467 Vss.n27 5.2005
R294 Vss.n469 Vss.n468 5.2005
R295 Vss.n468 Vss.n147 5.2005
R296 Vss.n382 Vss.n146 5.2005
R297 Vss.n474 Vss.n146 5.2005
R298 Vss.n381 Vss.n145 5.2005
R299 Vss.n475 Vss.n145 5.2005
R300 Vss.n155 Vss.n144 5.2005
R301 Vss.n476 Vss.n144 5.2005
R302 Vss.n370 Vss.n369 5.2005
R303 Vss.n369 Vss.n137 5.2005
R304 Vss.n371 Vss.n136 5.2005
R305 Vss.n482 Vss.n136 5.2005
R306 Vss.n372 Vss.n135 5.2005
R307 Vss.n483 Vss.n135 5.2005
R308 Vss.n368 Vss.n134 5.2005
R309 Vss.n484 Vss.n134 5.2005
R310 Vss.n367 Vss.n366 5.2005
R311 Vss.n366 Vss.n127 5.2005
R312 Vss.n365 Vss.n126 5.2005
R313 Vss.n490 Vss.n126 5.2005
R314 Vss.n364 Vss.n125 5.2005
R315 Vss.n491 Vss.n125 5.2005
R316 Vss.n160 Vss.n124 5.2005
R317 Vss.n492 Vss.n124 5.2005
R318 Vss.n351 Vss.n350 5.2005
R319 Vss.n350 Vss.n117 5.2005
R320 Vss.n352 Vss.n116 5.2005
R321 Vss.n498 Vss.n116 5.2005
R322 Vss.n353 Vss.n115 5.2005
R323 Vss.n499 Vss.n115 5.2005
R324 Vss.n349 Vss.n114 5.2005
R325 Vss.n500 Vss.n114 5.2005
R326 Vss.n348 Vss.n347 5.2005
R327 Vss.n347 Vss.n107 5.2005
R328 Vss.n346 Vss.n106 5.2005
R329 Vss.n506 Vss.n106 5.2005
R330 Vss.n345 Vss.n105 5.2005
R331 Vss.n507 Vss.n105 5.2005
R332 Vss.n167 Vss.n104 5.2005
R333 Vss.n508 Vss.n104 5.2005
R334 Vss.n333 Vss.n332 5.2005
R335 Vss.n332 Vss.n97 5.2005
R336 Vss.n334 Vss.n96 5.2005
R337 Vss.n514 Vss.n96 5.2005
R338 Vss.n335 Vss.n95 5.2005
R339 Vss.n515 Vss.n95 5.2005
R340 Vss.n331 Vss.n94 5.2005
R341 Vss.n516 Vss.n94 5.2005
R342 Vss.n330 Vss.n329 5.2005
R343 Vss.n329 Vss.n86 5.2005
R344 Vss.n328 Vss.n85 5.2005
R345 Vss.n522 Vss.n85 5.2005
R346 Vss.n327 Vss.n84 5.2005
R347 Vss.n523 Vss.n84 5.2005
R348 Vss.n325 Vss.n83 5.2005
R349 Vss.n524 Vss.n83 5.2005
R350 Vss.n324 Vss.n323 5.2005
R351 Vss.n323 Vss.n82 5.2005
R352 Vss.n322 Vss.n207 5.2005
R353 Vss.n322 Vss.n321 5.2005
R354 Vss.n310 Vss.n209 5.2005
R355 Vss.n210 Vss.n209 5.2005
R356 Vss.n312 Vss.n311 5.2005
R357 Vss.n313 Vss.n312 5.2005
R358 Vss.n218 Vss.n217 5.2005
R359 Vss.n217 Vss.n216 5.2005
R360 Vss.n304 Vss.n303 5.2005
R361 Vss.n303 Vss.n302 5.2005
R362 Vss.n221 Vss.n220 5.2005
R363 Vss.n222 Vss.n221 5.2005
R364 Vss.n293 Vss.n292 5.2005
R365 Vss.n294 Vss.n293 5.2005
R366 Vss.n230 Vss.n229 5.2005
R367 Vss.n229 Vss.n228 5.2005
R368 Vss.n288 Vss.n287 5.2005
R369 Vss.n287 Vss.n286 5.2005
R370 Vss.n233 Vss.n232 5.2005
R371 Vss.n234 Vss.n233 5.2005
R372 Vss.n277 Vss.n276 5.2005
R373 Vss.n278 Vss.n277 5.2005
R374 Vss.n242 Vss.n241 5.2005
R375 Vss.n241 Vss.n240 5.2005
R376 Vss.n272 Vss.n271 5.2005
R377 Vss.n271 Vss.n270 5.2005
R378 Vss.n245 Vss.n244 5.2005
R379 Vss.n246 Vss.n245 5.2005
R380 Vss.n261 Vss.n260 5.2005
R381 Vss.n262 Vss.n261 5.2005
R382 Vss.n254 Vss.n253 5.2005
R383 Vss.n253 Vss.n252 5.2005
R384 Vss.n32 Vss.n30 5.2005
R385 Vss.n30 Vss.n27 5.2005
R386 Vss.n471 Vss.n148 5.2005
R387 Vss.n148 Vss.n147 5.2005
R388 Vss.n473 Vss.n472 5.2005
R389 Vss.n474 Vss.n473 5.2005
R390 Vss.n143 Vss.n142 5.2005
R391 Vss.n475 Vss.n143 5.2005
R392 Vss.n478 Vss.n477 5.2005
R393 Vss.n477 Vss.n476 5.2005
R394 Vss.n479 Vss.n138 5.2005
R395 Vss.n138 Vss.n137 5.2005
R396 Vss.n481 Vss.n480 5.2005
R397 Vss.n482 Vss.n481 5.2005
R398 Vss.n133 Vss.n132 5.2005
R399 Vss.n483 Vss.n133 5.2005
R400 Vss.n486 Vss.n485 5.2005
R401 Vss.n485 Vss.n484 5.2005
R402 Vss.n487 Vss.n128 5.2005
R403 Vss.n128 Vss.n127 5.2005
R404 Vss.n489 Vss.n488 5.2005
R405 Vss.n490 Vss.n489 5.2005
R406 Vss.n123 Vss.n122 5.2005
R407 Vss.n491 Vss.n123 5.2005
R408 Vss.n494 Vss.n493 5.2005
R409 Vss.n493 Vss.n492 5.2005
R410 Vss.n495 Vss.n118 5.2005
R411 Vss.n118 Vss.n117 5.2005
R412 Vss.n497 Vss.n496 5.2005
R413 Vss.n498 Vss.n497 5.2005
R414 Vss.n113 Vss.n112 5.2005
R415 Vss.n499 Vss.n113 5.2005
R416 Vss.n502 Vss.n501 5.2005
R417 Vss.n501 Vss.n500 5.2005
R418 Vss.n503 Vss.n108 5.2005
R419 Vss.n108 Vss.n107 5.2005
R420 Vss.n505 Vss.n504 5.2005
R421 Vss.n506 Vss.n505 5.2005
R422 Vss.n103 Vss.n102 5.2005
R423 Vss.n507 Vss.n103 5.2005
R424 Vss.n510 Vss.n509 5.2005
R425 Vss.n509 Vss.n508 5.2005
R426 Vss.n511 Vss.n98 5.2005
R427 Vss.n98 Vss.n97 5.2005
R428 Vss.n513 Vss.n512 5.2005
R429 Vss.n514 Vss.n513 5.2005
R430 Vss.n93 Vss.n92 5.2005
R431 Vss.n515 Vss.n93 5.2005
R432 Vss.n518 Vss.n517 5.2005
R433 Vss.n517 Vss.n516 5.2005
R434 Vss.n519 Vss.n87 5.2005
R435 Vss.n87 Vss.n86 5.2005
R436 Vss.n521 Vss.n520 5.2005
R437 Vss.n522 Vss.n521 5.2005
R438 Vss.n81 Vss.n79 5.2005
R439 Vss.n523 Vss.n81 5.2005
R440 Vss.n526 Vss.n525 5.2005
R441 Vss.n525 Vss.n524 5.2005
R442 Vss.n80 Vss.n78 5.2005
R443 Vss.n82 Vss.n80 5.2005
R444 Vss.n320 Vss.n319 5.2005
R445 Vss.n321 Vss.n320 5.2005
R446 Vss.n212 Vss.n211 5.2005
R447 Vss.n211 Vss.n210 5.2005
R448 Vss.n315 Vss.n314 5.2005
R449 Vss.n314 Vss.n313 5.2005
R450 Vss.n215 Vss.n214 5.2005
R451 Vss.n216 Vss.n215 5.2005
R452 Vss.n301 Vss.n300 5.2005
R453 Vss.n302 Vss.n301 5.2005
R454 Vss.n224 Vss.n223 5.2005
R455 Vss.n223 Vss.n222 5.2005
R456 Vss.n296 Vss.n295 5.2005
R457 Vss.n295 Vss.n294 5.2005
R458 Vss.n227 Vss.n226 5.2005
R459 Vss.n228 Vss.n227 5.2005
R460 Vss.n285 Vss.n284 5.2005
R461 Vss.n286 Vss.n285 5.2005
R462 Vss.n236 Vss.n235 5.2005
R463 Vss.n235 Vss.n234 5.2005
R464 Vss.n280 Vss.n279 5.2005
R465 Vss.n279 Vss.n278 5.2005
R466 Vss.n239 Vss.n238 5.2005
R467 Vss.n240 Vss.n239 5.2005
R468 Vss.n269 Vss.n268 5.2005
R469 Vss.n270 Vss.n269 5.2005
R470 Vss.n248 Vss.n247 5.2005
R471 Vss.n247 Vss.n246 5.2005
R472 Vss.n264 Vss.n263 5.2005
R473 Vss.n263 Vss.n262 5.2005
R474 Vss.n251 Vss.n250 5.2005
R475 Vss.n398 Vss.n397 5.2005
R476 Vss.n398 Vss.n390 5.2005
R477 Vss.n391 Vss.n40 5.2005
R478 Vss.n562 Vss.n40 5.2005
R479 Vss.n559 Vss.n43 5.2005
R480 Vss.n390 Vss.n43 5.2005
R481 Vss.n561 Vss.n560 5.2005
R482 Vss.n562 Vss.n561 5.2005
R483 Vss.n65 Vss.n58 5.2005
R484 Vss.n58 Vss.n22 5.2005
R485 Vss.n67 Vss.n66 5.2005
R486 Vss.n542 Vss.n67 5.2005
R487 Vss.n56 Vss.n54 5.2005
R488 Vss.n56 Vss.n22 5.2005
R489 Vss.n544 Vss.n543 5.2005
R490 Vss.n543 Vss.n542 5.2005
R491 Vss.n538 Vss.n23 5.2005
R492 Vss.n574 Vss.n23 5.2005
R493 Vss.n540 Vss.n539 5.2005
R494 Vss.n541 Vss.n540 5.2005
R495 Vss.n69 Vss.n68 5.2005
R496 Vss.n68 Vss.n57 5.2005
R497 Vss.n434 Vss.n433 5.2005
R498 Vss.n433 Vss.n432 5.2005
R499 Vss.n435 Vss.n424 5.2005
R500 Vss.n430 Vss.n424 5.2005
R501 Vss.n437 Vss.n436 5.2005
R502 Vss.n439 Vss.n437 5.2005
R503 Vss.n423 Vss.n422 5.2005
R504 Vss.n442 Vss.n423 5.2005
R505 Vss.n445 Vss.n444 5.2005
R506 Vss.n444 Vss.n443 5.2005
R507 Vss.n446 Vss.n7 5.2005
R508 Vss.n591 Vss.n7 5.2005
R509 Vss.n448 Vss.n447 5.2005
R510 Vss.n447 Vss.n5 5.2005
R511 Vss.n449 Vss.n413 5.2005
R512 Vss.n413 Vss.n412 5.2005
R513 Vss.n451 Vss.n450 5.2005
R514 Vss.n452 Vss.n451 5.2005
R515 Vss.n414 Vss.n389 5.2005
R516 Vss.n410 Vss.n389 5.2005
R517 Vss.n459 Vss.n388 5.2005
R518 Vss.n459 Vss.n458 5.2005
R519 Vss.n461 Vss.n460 5.2005
R520 Vss.n460 Vss.n41 5.2005
R521 Vss.n462 Vss.n39 5.2005
R522 Vss.n563 Vss.n39 5.2005
R523 Vss.n464 Vss.n463 5.2005
R524 Vss.n463 Vss.n38 5.2005
R525 Vss.n465 Vss.n28 5.2005
R526 Vss.n569 Vss.n28 5.2005
R527 Vss.n576 Vss.n575 5.2005
R528 Vss.n575 Vss.n574 5.2005
R529 Vss.n20 Vss.n18 5.2005
R530 Vss.n541 Vss.n20 5.2005
R531 Vss.n580 Vss.n17 5.2005
R532 Vss.n57 Vss.n17 5.2005
R533 Vss.n581 Vss.n16 5.2005
R534 Vss.n432 Vss.n16 5.2005
R535 Vss.n582 Vss.n15 5.2005
R536 Vss.n430 Vss.n15 5.2005
R537 Vss.n438 Vss.n13 5.2005
R538 Vss.n439 Vss.n438 5.2005
R539 Vss.n586 Vss.n12 5.2005
R540 Vss.n442 Vss.n12 5.2005
R541 Vss.n587 Vss.n10 5.2005
R542 Vss.n443 Vss.n10 5.2005
R543 Vss.n590 Vss.n589 5.2005
R544 Vss.n591 Vss.n590 5.2005
R545 Vss.n11 Vss.n9 5.2005
R546 Vss.n9 Vss.n5 5.2005
R547 Vss.n409 Vss.n408 5.2005
R548 Vss.n412 Vss.n409 5.2005
R549 Vss.n454 Vss.n453 5.2005
R550 Vss.n453 Vss.n452 5.2005
R551 Vss.n455 Vss.n401 5.2005
R552 Vss.n410 Vss.n401 5.2005
R553 Vss.n457 Vss.n456 5.2005
R554 Vss.n458 Vss.n457 5.2005
R555 Vss.n37 Vss.n36 5.2005
R556 Vss.n41 Vss.n37 5.2005
R557 Vss.n565 Vss.n564 5.2005
R558 Vss.n564 Vss.n563 5.2005
R559 Vss.n566 Vss.n31 5.2005
R560 Vss.n38 Vss.n31 5.2005
R561 Vss.n568 Vss.n567 5.2005
R562 Vss.n569 Vss.n568 5.2005
R563 Vss.n551 Vss.n50 5.2005
R564 Vss.n50 Vss.n8 5.2005
R565 Vss.n552 Vss.n6 5.2005
R566 Vss.n592 Vss.n6 5.2005
R567 Vss.n8 Vss.n3 5.2005
R568 Vss.n593 Vss.n592 5.2005
R569 Vss.n64 Vss.n63 5.19319
R570 Vss.n396 Vss.n46 5.19319
R571 Vss.n71 Vss.n19 5.12952
R572 Vss.n595 Vss.n1 5.12001
R573 Vss.n595 Vss.n0 5.11219
R574 Vss.n537 Vss.n536 5.04833
R575 Vss.n63 Vss.n62 5.00286
R576 Vss.n557 Vss.n46 5.00286
R577 Vss.n554 Vss.n1 5.00286
R578 Vss.n546 Vss.n52 5.00286
R579 Vss.n394 Vss.n393 5.00286
R580 Vss.n549 Vss.n0 5.00286
R581 Vss.n536 Vss.n535 4.7183
R582 Vss.n60 Vss.n54 4.5005
R583 Vss.n545 Vss.n544 4.5005
R584 Vss.n65 Vss.n64 4.5005
R585 Vss.n66 Vss.n59 4.5005
R586 Vss.n559 Vss.n558 4.5005
R587 Vss.n560 Vss.n44 4.5005
R588 Vss.n397 Vss.n396 4.5005
R589 Vss.n395 Vss.n391 4.5005
R590 Vss.n532 Vss.n531 4.5005
R591 Vss.n326 Vss.n79 4.5005
R592 Vss.n520 Vss.n88 4.5005
R593 Vss.n519 Vss.n90 4.5005
R594 Vss.n518 Vss.n91 4.5005
R595 Vss.n336 Vss.n92 4.5005
R596 Vss.n512 Vss.n99 4.5005
R597 Vss.n511 Vss.n100 4.5005
R598 Vss.n510 Vss.n101 4.5005
R599 Vss.n344 Vss.n102 4.5005
R600 Vss.n504 Vss.n109 4.5005
R601 Vss.n503 Vss.n110 4.5005
R602 Vss.n502 Vss.n111 4.5005
R603 Vss.n354 Vss.n112 4.5005
R604 Vss.n496 Vss.n119 4.5005
R605 Vss.n495 Vss.n120 4.5005
R606 Vss.n494 Vss.n121 4.5005
R607 Vss.n363 Vss.n122 4.5005
R608 Vss.n488 Vss.n129 4.5005
R609 Vss.n487 Vss.n130 4.5005
R610 Vss.n486 Vss.n131 4.5005
R611 Vss.n373 Vss.n132 4.5005
R612 Vss.n480 Vss.n139 4.5005
R613 Vss.n479 Vss.n140 4.5005
R614 Vss.n478 Vss.n141 4.5005
R615 Vss.n380 Vss.n142 4.5005
R616 Vss.n472 Vss.n149 4.5005
R617 Vss.n471 Vss.n470 4.5005
R618 Vss.n151 Vss.n32 4.5005
R619 Vss.n567 Vss.n33 4.5005
R620 Vss.n566 Vss.n34 4.5005
R621 Vss.n565 Vss.n35 4.5005
R622 Vss.n402 Vss.n36 4.5005
R623 Vss.n456 Vss.n403 4.5005
R624 Vss.n455 Vss.n404 4.5005
R625 Vss.n454 Vss.n405 4.5005
R626 Vss.n408 Vss.n407 4.5005
R627 Vss.n406 Vss.n11 4.5005
R628 Vss.n265 Vss.n264 4.5005
R629 Vss.n266 Vss.n248 4.5005
R630 Vss.n268 Vss.n267 4.5005
R631 Vss.n238 Vss.n237 4.5005
R632 Vss.n281 Vss.n280 4.5005
R633 Vss.n282 Vss.n236 4.5005
R634 Vss.n284 Vss.n283 4.5005
R635 Vss.n226 Vss.n225 4.5005
R636 Vss.n297 Vss.n296 4.5005
R637 Vss.n298 Vss.n224 4.5005
R638 Vss.n300 Vss.n299 4.5005
R639 Vss.n214 Vss.n213 4.5005
R640 Vss.n316 Vss.n315 4.5005
R641 Vss.n317 Vss.n212 4.5005
R642 Vss.n319 Vss.n318 4.5005
R643 Vss.n78 Vss.n77 4.5005
R644 Vss.n527 Vss.n526 4.5005
R645 Vss.n250 Vss.n249 4.5005
R646 Vss.n260 Vss.n259 4.5005
R647 Vss.n244 Vss.n243 4.5005
R648 Vss.n273 Vss.n272 4.5005
R649 Vss.n274 Vss.n242 4.5005
R650 Vss.n276 Vss.n275 4.5005
R651 Vss.n232 Vss.n231 4.5005
R652 Vss.n289 Vss.n288 4.5005
R653 Vss.n290 Vss.n230 4.5005
R654 Vss.n292 Vss.n291 4.5005
R655 Vss.n220 Vss.n219 4.5005
R656 Vss.n305 Vss.n304 4.5005
R657 Vss.n306 Vss.n218 4.5005
R658 Vss.n311 Vss.n307 4.5005
R659 Vss.n310 Vss.n309 4.5005
R660 Vss.n308 Vss.n207 4.5005
R661 Vss.n324 Vss.n208 4.5005
R662 Vss.n325 Vss.n74 4.5005
R663 Vss.n327 Vss.n326 4.5005
R664 Vss.n328 Vss.n88 4.5005
R665 Vss.n330 Vss.n90 4.5005
R666 Vss.n331 Vss.n91 4.5005
R667 Vss.n336 Vss.n335 4.5005
R668 Vss.n334 Vss.n99 4.5005
R669 Vss.n333 Vss.n100 4.5005
R670 Vss.n167 Vss.n101 4.5005
R671 Vss.n345 Vss.n344 4.5005
R672 Vss.n346 Vss.n109 4.5005
R673 Vss.n348 Vss.n110 4.5005
R674 Vss.n349 Vss.n111 4.5005
R675 Vss.n354 Vss.n353 4.5005
R676 Vss.n352 Vss.n119 4.5005
R677 Vss.n351 Vss.n120 4.5005
R678 Vss.n160 Vss.n121 4.5005
R679 Vss.n364 Vss.n363 4.5005
R680 Vss.n365 Vss.n129 4.5005
R681 Vss.n367 Vss.n130 4.5005
R682 Vss.n368 Vss.n131 4.5005
R683 Vss.n373 Vss.n372 4.5005
R684 Vss.n371 Vss.n139 4.5005
R685 Vss.n370 Vss.n140 4.5005
R686 Vss.n155 Vss.n141 4.5005
R687 Vss.n381 Vss.n380 4.5005
R688 Vss.n382 Vss.n149 4.5005
R689 Vss.n470 Vss.n469 4.5005
R690 Vss.n466 Vss.n383 4.5005
R691 Vss.n465 Vss.n384 4.5005
R692 Vss.n464 Vss.n385 4.5005
R693 Vss.n462 Vss.n386 4.5005
R694 Vss.n461 Vss.n387 4.5005
R695 Vss.n415 Vss.n388 4.5005
R696 Vss.n416 Vss.n414 4.5005
R697 Vss.n450 Vss.n417 4.5005
R698 Vss.n449 Vss.n418 4.5005
R699 Vss.n448 Vss.n419 4.5005
R700 Vss.n446 Vss.n420 4.5005
R701 Vss.n445 Vss.n421 4.5005
R702 Vss.n425 Vss.n422 4.5005
R703 Vss.n436 Vss.n426 4.5005
R704 Vss.n435 Vss.n427 4.5005
R705 Vss.n434 Vss.n429 4.5005
R706 Vss.n428 Vss.n69 4.5005
R707 Vss.n539 Vss.n70 4.5005
R708 Vss.n538 Vss.n537 4.5005
R709 Vss.n258 Vss.n254 4.5005
R710 Vss.n551 Vss.n550 4.5005
R711 Vss.n553 Vss.n552 4.5005
R712 Vss.n586 Vss.n585 4.5005
R713 Vss.n584 Vss.n13 4.5005
R714 Vss.n583 Vss.n582 4.5005
R715 Vss.n581 Vss.n14 4.5005
R716 Vss.n580 Vss.n579 4.5005
R717 Vss.n578 Vss.n18 4.5005
R718 Vss.n577 Vss.n576 4.5005
R719 Vss.n557 Vss.n556 4.5005
R720 Vss.n47 Vss.n45 4.5005
R721 Vss.n393 Vss.n392 4.5005
R722 Vss.n549 Vss.n548 4.5005
R723 Vss.n49 Vss.n48 4.5005
R724 Vss.n555 Vss.n554 4.5005
R725 Vss.n62 Vss.n61 4.5005
R726 Vss.n53 Vss.n51 4.5005
R727 Vss.n547 Vss.n546 4.5005
R728 Vss.n592 Vss.n591 3.61362
R729 Vss.n443 Vss.n8 3.61362
R730 Vss.n595 Vss.n594 3.28078
R731 Vss.n255 Vss.n252 3.26114
R732 Vss.n594 Vss.n593 3.14293
R733 Vss.n594 Vss.n3 3.14293
R734 Vss.n357 Vss.n356 2.80819
R735 Vss.n358 Vss.n357 2.80819
R736 Vss.n535 Vss.n72 2.6735
R737 Vss.n588 Vss.n2 2.21557
R738 Vss.n532 Vss.n530 2.1983
R739 Vss.n255 Vss.n251 1.82789
R740 Vss.n153 Vss.n2 1.23277
R741 Vss.n392 Vss 1.1597
R742 Vss.n394 Vss.n42 0.743357
R743 Vss.n42 Vss.n29 0.743357
R744 Vss.n399 Vss.n46 0.743357
R745 Vss.n400 Vss.n399 0.743357
R746 Vss.n55 Vss.n52 0.743357
R747 Vss.n431 Vss.n55 0.743357
R748 Vss.n63 Vss.n24 0.743357
R749 Vss.n573 Vss.n24 0.743357
R750 Vss.n440 Vss.n0 0.743357
R751 Vss.n441 Vss.n440 0.743357
R752 Vss.n4 Vss.n1 0.743357
R753 Vss.n411 Vss.n4 0.743357
R754 Vss.n530 Vss.n529 0.573125
R755 Vss.n152 Vss.n150 0.483125
R756 Vss.n529 Vss.n528 0.483125
R757 Vss.n257 Vss.n256 0.473227
R758 Vss.n71 Vss.n21 0.473227
R759 Vss.n573 Vss.n21 0.473227
R760 Vss.n383 Vss.n72 0.44735
R761 Vss.n150 Vss.n72 0.393125
R762 Vss.n556 Vss.n555 0.3515
R763 Vss.n548 Vss.n547 0.3515
R764 Vss.n536 Vss.n71 0.29887
R765 Vss.n178 Vss.n156 0.28625
R766 Vss.n178 Vss.n177 0.28175
R767 Vss.n180 Vss.n179 0.28175
R768 Vss.n181 Vss.n159 0.28175
R769 Vss.n182 Vss.n158 0.28175
R770 Vss.n184 Vss.n183 0.28175
R771 Vss.n186 Vss.n185 0.28175
R772 Vss.n187 Vss.n162 0.28175
R773 Vss.n188 Vss.n161 0.28175
R774 Vss.n190 Vss.n189 0.28175
R775 Vss.n192 Vss.n191 0.28175
R776 Vss.n193 Vss.n166 0.28175
R777 Vss.n194 Vss.n165 0.28175
R778 Vss.n196 Vss.n195 0.28175
R779 Vss.n198 Vss.n197 0.28175
R780 Vss.n199 Vss.n169 0.28175
R781 Vss.n200 Vss.n168 0.28175
R782 Vss.n202 Vss.n201 0.28175
R783 Vss.n204 Vss.n203 0.28175
R784 Vss.n206 Vss.n205 0.28175
R785 Vss.n176 Vss.n173 0.28175
R786 Vss.n175 Vss.n174 0.28175
R787 Vss.n89 Vss.n73 0.28175
R788 Vss.n533 Vss.n532 0.2705
R789 Vss.n152 Vss.n151 0.26735
R790 Vss.n577 Vss.n19 0.2255
R791 Vss.n153 Vss.n152 0.219838
R792 Vss.n528 Vss.n527 0.20615
R793 Vss.n530 Vss.n74 0.20615
R794 Vss.n357 Vss.n163 0.1684
R795 Vss.n544 Vss.n54 0.1445
R796 Vss.n64 Vss.n59 0.1445
R797 Vss.n66 Vss.n65 0.1445
R798 Vss.n560 Vss.n559 0.1445
R799 Vss.n396 Vss.n395 0.1445
R800 Vss.n397 Vss.n391 0.1445
R801 Vss.n151 Vss.n33 0.1445
R802 Vss.n34 Vss.n33 0.1445
R803 Vss.n35 Vss.n34 0.1445
R804 Vss.n402 Vss.n35 0.1445
R805 Vss.n403 Vss.n402 0.1445
R806 Vss.n404 Vss.n403 0.1445
R807 Vss.n405 Vss.n404 0.1445
R808 Vss.n407 Vss.n405 0.1445
R809 Vss.n407 Vss.n406 0.1445
R810 Vss.n384 Vss.n383 0.1445
R811 Vss.n385 Vss.n384 0.1445
R812 Vss.n386 Vss.n385 0.1445
R813 Vss.n387 Vss.n386 0.1445
R814 Vss.n415 Vss.n387 0.1445
R815 Vss.n416 Vss.n415 0.1445
R816 Vss.n417 Vss.n416 0.1445
R817 Vss.n418 Vss.n417 0.1445
R818 Vss.n419 Vss.n418 0.1445
R819 Vss.n420 Vss.n419 0.1445
R820 Vss.n421 Vss.n420 0.1445
R821 Vss.n425 Vss.n421 0.1445
R822 Vss.n426 Vss.n425 0.1445
R823 Vss.n427 Vss.n426 0.1445
R824 Vss.n429 Vss.n427 0.1445
R825 Vss.n429 Vss.n428 0.1445
R826 Vss.n428 Vss.n70 0.1445
R827 Vss.n537 Vss.n70 0.1445
R828 Vss.n264 Vss.n250 0.1445
R829 Vss.n264 Vss.n248 0.1445
R830 Vss.n268 Vss.n248 0.1445
R831 Vss.n268 Vss.n238 0.1445
R832 Vss.n280 Vss.n238 0.1445
R833 Vss.n280 Vss.n236 0.1445
R834 Vss.n284 Vss.n236 0.1445
R835 Vss.n284 Vss.n226 0.1445
R836 Vss.n296 Vss.n226 0.1445
R837 Vss.n296 Vss.n224 0.1445
R838 Vss.n300 Vss.n224 0.1445
R839 Vss.n300 Vss.n214 0.1445
R840 Vss.n315 Vss.n214 0.1445
R841 Vss.n315 Vss.n212 0.1445
R842 Vss.n319 Vss.n212 0.1445
R843 Vss.n319 Vss.n78 0.1445
R844 Vss.n526 Vss.n78 0.1445
R845 Vss.n526 Vss.n79 0.1445
R846 Vss.n520 Vss.n79 0.1445
R847 Vss.n520 Vss.n519 0.1445
R848 Vss.n519 Vss.n518 0.1445
R849 Vss.n518 Vss.n92 0.1445
R850 Vss.n512 Vss.n92 0.1445
R851 Vss.n512 Vss.n511 0.1445
R852 Vss.n511 Vss.n510 0.1445
R853 Vss.n510 Vss.n102 0.1445
R854 Vss.n504 Vss.n102 0.1445
R855 Vss.n504 Vss.n503 0.1445
R856 Vss.n503 Vss.n502 0.1445
R857 Vss.n502 Vss.n112 0.1445
R858 Vss.n496 Vss.n112 0.1445
R859 Vss.n496 Vss.n495 0.1445
R860 Vss.n495 Vss.n494 0.1445
R861 Vss.n494 Vss.n122 0.1445
R862 Vss.n488 Vss.n122 0.1445
R863 Vss.n488 Vss.n487 0.1445
R864 Vss.n487 Vss.n486 0.1445
R865 Vss.n486 Vss.n132 0.1445
R866 Vss.n480 Vss.n132 0.1445
R867 Vss.n480 Vss.n479 0.1445
R868 Vss.n479 Vss.n478 0.1445
R869 Vss.n478 Vss.n142 0.1445
R870 Vss.n472 Vss.n142 0.1445
R871 Vss.n472 Vss.n471 0.1445
R872 Vss.n471 Vss.n32 0.1445
R873 Vss.n567 Vss.n32 0.1445
R874 Vss.n567 Vss.n566 0.1445
R875 Vss.n566 Vss.n565 0.1445
R876 Vss.n565 Vss.n36 0.1445
R877 Vss.n456 Vss.n36 0.1445
R878 Vss.n456 Vss.n455 0.1445
R879 Vss.n455 Vss.n454 0.1445
R880 Vss.n454 Vss.n408 0.1445
R881 Vss.n408 Vss.n11 0.1445
R882 Vss.n589 Vss.n11 0.1445
R883 Vss.n587 Vss.n586 0.1445
R884 Vss.n586 Vss.n13 0.1445
R885 Vss.n582 Vss.n13 0.1445
R886 Vss.n582 Vss.n581 0.1445
R887 Vss.n581 Vss.n580 0.1445
R888 Vss.n580 Vss.n18 0.1445
R889 Vss.n576 Vss.n18 0.1445
R890 Vss.n265 Vss.n249 0.1445
R891 Vss.n266 Vss.n265 0.1445
R892 Vss.n267 Vss.n266 0.1445
R893 Vss.n267 Vss.n237 0.1445
R894 Vss.n281 Vss.n237 0.1445
R895 Vss.n282 Vss.n281 0.1445
R896 Vss.n283 Vss.n282 0.1445
R897 Vss.n283 Vss.n225 0.1445
R898 Vss.n297 Vss.n225 0.1445
R899 Vss.n298 Vss.n297 0.1445
R900 Vss.n299 Vss.n298 0.1445
R901 Vss.n299 Vss.n213 0.1445
R902 Vss.n316 Vss.n213 0.1445
R903 Vss.n317 Vss.n316 0.1445
R904 Vss.n318 Vss.n317 0.1445
R905 Vss.n318 Vss.n77 0.1445
R906 Vss.n527 Vss.n77 0.1445
R907 Vss.n259 Vss.n258 0.1445
R908 Vss.n259 Vss.n243 0.1445
R909 Vss.n273 Vss.n243 0.1445
R910 Vss.n274 Vss.n273 0.1445
R911 Vss.n275 Vss.n274 0.1445
R912 Vss.n275 Vss.n231 0.1445
R913 Vss.n289 Vss.n231 0.1445
R914 Vss.n290 Vss.n289 0.1445
R915 Vss.n291 Vss.n290 0.1445
R916 Vss.n291 Vss.n219 0.1445
R917 Vss.n305 Vss.n219 0.1445
R918 Vss.n306 Vss.n305 0.1445
R919 Vss.n307 Vss.n306 0.1445
R920 Vss.n309 Vss.n307 0.1445
R921 Vss.n309 Vss.n308 0.1445
R922 Vss.n308 Vss.n208 0.1445
R923 Vss.n208 Vss.n74 0.1445
R924 Vss.n260 Vss.n254 0.1445
R925 Vss.n260 Vss.n244 0.1445
R926 Vss.n272 Vss.n244 0.1445
R927 Vss.n272 Vss.n242 0.1445
R928 Vss.n276 Vss.n242 0.1445
R929 Vss.n276 Vss.n232 0.1445
R930 Vss.n288 Vss.n232 0.1445
R931 Vss.n288 Vss.n230 0.1445
R932 Vss.n292 Vss.n230 0.1445
R933 Vss.n292 Vss.n220 0.1445
R934 Vss.n304 Vss.n220 0.1445
R935 Vss.n304 Vss.n218 0.1445
R936 Vss.n311 Vss.n218 0.1445
R937 Vss.n311 Vss.n310 0.1445
R938 Vss.n310 Vss.n207 0.1445
R939 Vss.n324 Vss.n207 0.1445
R940 Vss.n325 Vss.n324 0.1445
R941 Vss.n327 Vss.n325 0.1445
R942 Vss.n328 Vss.n327 0.1445
R943 Vss.n330 Vss.n328 0.1445
R944 Vss.n331 Vss.n330 0.1445
R945 Vss.n335 Vss.n331 0.1445
R946 Vss.n335 Vss.n334 0.1445
R947 Vss.n334 Vss.n333 0.1445
R948 Vss.n333 Vss.n167 0.1445
R949 Vss.n345 Vss.n167 0.1445
R950 Vss.n346 Vss.n345 0.1445
R951 Vss.n348 Vss.n346 0.1445
R952 Vss.n349 Vss.n348 0.1445
R953 Vss.n353 Vss.n349 0.1445
R954 Vss.n353 Vss.n352 0.1445
R955 Vss.n352 Vss.n351 0.1445
R956 Vss.n351 Vss.n160 0.1445
R957 Vss.n364 Vss.n160 0.1445
R958 Vss.n365 Vss.n364 0.1445
R959 Vss.n367 Vss.n365 0.1445
R960 Vss.n368 Vss.n367 0.1445
R961 Vss.n372 Vss.n368 0.1445
R962 Vss.n372 Vss.n371 0.1445
R963 Vss.n371 Vss.n370 0.1445
R964 Vss.n370 Vss.n155 0.1445
R965 Vss.n381 Vss.n155 0.1445
R966 Vss.n382 Vss.n381 0.1445
R967 Vss.n469 Vss.n382 0.1445
R968 Vss.n469 Vss.n466 0.1445
R969 Vss.n466 Vss.n465 0.1445
R970 Vss.n465 Vss.n464 0.1445
R971 Vss.n464 Vss.n462 0.1445
R972 Vss.n462 Vss.n461 0.1445
R973 Vss.n461 Vss.n388 0.1445
R974 Vss.n414 Vss.n388 0.1445
R975 Vss.n450 Vss.n414 0.1445
R976 Vss.n450 Vss.n449 0.1445
R977 Vss.n449 Vss.n448 0.1445
R978 Vss.n448 Vss.n446 0.1445
R979 Vss.n446 Vss.n445 0.1445
R980 Vss.n445 Vss.n422 0.1445
R981 Vss.n436 Vss.n422 0.1445
R982 Vss.n436 Vss.n435 0.1445
R983 Vss.n435 Vss.n434 0.1445
R984 Vss.n434 Vss.n69 0.1445
R985 Vss.n539 Vss.n69 0.1445
R986 Vss.n539 Vss.n538 0.1445
R987 Vss.n552 Vss.n551 0.1445
R988 Vss.n585 Vss.n584 0.1445
R989 Vss.n584 Vss.n583 0.1445
R990 Vss.n583 Vss.n14 0.1445
R991 Vss.n579 Vss.n14 0.1445
R992 Vss.n579 Vss.n578 0.1445
R993 Vss.n578 Vss.n577 0.1445
R994 Vss.n595 Vss.n2 0.107176
R995 Vss.n531 Vss 0.0905
R996 Vss.n596 Vss 0.0905
R997 Vss.n392 Vss.n47 0.0725
R998 Vss.n556 Vss.n47 0.0725
R999 Vss.n555 Vss.n48 0.0725
R1000 Vss.n548 Vss.n48 0.0725
R1001 Vss.n547 Vss.n51 0.0725
R1002 Vss.n61 Vss.n51 0.0725
R1003 Vss.n589 Vss.n588 0.0718661
R1004 Vss.n588 Vss.n587 0.0718661
R1005 Vss.n585 Vss.n2 0.0671
R1006 Vss.n406 Vss.n2 0.0599
R1007 Vss.n531 Vss 0.023
R1008 Vss Vss.n596 0.023
R1009 Vss.n546 Vss.n545 0.0102035
R1010 Vss.n545 Vss.n53 0.0102035
R1011 Vss.n60 Vss.n53 0.0102035
R1012 Vss.n62 Vss.n60 0.0102035
R1013 Vss.n393 Vss.n44 0.0102035
R1014 Vss.n45 Vss.n44 0.0102035
R1015 Vss.n558 Vss.n45 0.0102035
R1016 Vss.n558 Vss.n557 0.0102035
R1017 Vss.n554 Vss.n553 0.0102035
R1018 Vss.n553 Vss.n49 0.0102035
R1019 Vss.n550 Vss.n49 0.0102035
R1020 Vss.n550 Vss.n549 0.0102035
R1021 Vss.n175 Vss.n73 0.005
R1022 Vss.n176 Vss.n175 0.005
R1023 Vss.n205 Vss.n176 0.005
R1024 Vss.n205 Vss.n204 0.005
R1025 Vss.n204 Vss.n202 0.005
R1026 Vss.n202 Vss.n200 0.005
R1027 Vss.n200 Vss.n199 0.005
R1028 Vss.n199 Vss.n198 0.005
R1029 Vss.n198 Vss.n196 0.005
R1030 Vss.n196 Vss.n194 0.005
R1031 Vss.n194 Vss.n193 0.005
R1032 Vss.n193 Vss.n192 0.005
R1033 Vss.n192 Vss.n190 0.005
R1034 Vss.n190 Vss.n188 0.005
R1035 Vss.n188 Vss.n187 0.005
R1036 Vss.n187 Vss.n186 0.005
R1037 Vss.n186 Vss.n184 0.005
R1038 Vss.n184 Vss.n182 0.005
R1039 Vss.n182 Vss.n181 0.005
R1040 Vss.n181 Vss.n180 0.005
R1041 Vss.n180 Vss.n178 0.005
R1042 Vss.n326 Vss.n88 0.00397994
R1043 Vss.n380 Vss.n149 0.00397994
R1044 Vss.n470 Vss.n149 0.00397994
R1045 Vss.n89 Vss.n88 0.00324045
R1046 Vss.n174 Vss.n90 0.00324045
R1047 Vss.n173 Vss.n91 0.00324045
R1048 Vss.n336 Vss.n206 0.00324045
R1049 Vss.n203 Vss.n99 0.00324045
R1050 Vss.n201 Vss.n100 0.00324045
R1051 Vss.n168 Vss.n101 0.00324045
R1052 Vss.n344 Vss.n169 0.00324045
R1053 Vss.n197 Vss.n109 0.00324045
R1054 Vss.n195 Vss.n110 0.00324045
R1055 Vss.n165 Vss.n111 0.00324045
R1056 Vss.n354 Vss.n166 0.00324045
R1057 Vss.n191 Vss.n119 0.00324045
R1058 Vss.n189 Vss.n120 0.00324045
R1059 Vss.n161 Vss.n121 0.00324045
R1060 Vss.n363 Vss.n162 0.00324045
R1061 Vss.n185 Vss.n129 0.00324045
R1062 Vss.n183 Vss.n130 0.00324045
R1063 Vss.n158 Vss.n131 0.00324045
R1064 Vss.n373 Vss.n159 0.00324045
R1065 Vss.n179 Vss.n139 0.00324045
R1066 Vss.n177 Vss.n140 0.00324045
R1067 Vss.n156 Vss.n141 0.00324045
R1068 Vss.n529 Vss.n75 0.00158748
R1069 Vss.n90 Vss.n89 0.00123949
R1070 Vss.n174 Vss.n91 0.00123949
R1071 Vss.n336 Vss.n173 0.00123949
R1072 Vss.n206 Vss.n99 0.00123949
R1073 Vss.n203 Vss.n100 0.00123949
R1074 Vss.n201 Vss.n101 0.00123949
R1075 Vss.n344 Vss.n168 0.00123949
R1076 Vss.n169 Vss.n109 0.00123949
R1077 Vss.n197 Vss.n110 0.00123949
R1078 Vss.n195 Vss.n111 0.00123949
R1079 Vss.n354 Vss.n165 0.00123949
R1080 Vss.n166 Vss.n119 0.00123949
R1081 Vss.n191 Vss.n120 0.00123949
R1082 Vss.n189 Vss.n121 0.00123949
R1083 Vss.n363 Vss.n161 0.00123949
R1084 Vss.n162 Vss.n129 0.00123949
R1085 Vss.n185 Vss.n130 0.00123949
R1086 Vss.n183 Vss.n131 0.00123949
R1087 Vss.n373 Vss.n158 0.00123949
R1088 Vss.n159 Vss.n139 0.00123949
R1089 Vss.n179 Vss.n140 0.00123949
R1090 Vss.n177 Vss.n141 0.00123949
R1091 Vss.n380 Vss.n156 0.00123949
R1092 Vss.n326 Vss.n75 0.00102199
R1093 Vss.n470 Vss.n150 0.000630498
R1094 Vdd.n47 Vdd.n46 521.494
R1095 Vdd.n46 Vdd.n38 521.494
R1096 Vdd.n30 Vdd.n29 521.494
R1097 Vdd.n29 Vdd.n28 521.494
R1098 Vdd.n13 Vdd.n12 521.494
R1099 Vdd.n12 Vdd.n11 521.494
R1100 Vdd.n45 Vdd.n36 62.1255
R1101 Vdd.n45 Vdd.n44 62.1255
R1102 Vdd.n39 Vdd.n37 62.1255
R1103 Vdd.n48 Vdd.n37 62.1255
R1104 Vdd.n31 Vdd.n20 62.1255
R1105 Vdd.n27 Vdd.n20 62.1255
R1106 Vdd.n22 Vdd.n21 62.1255
R1107 Vdd.n21 Vdd.n19 62.1255
R1108 Vdd.n14 Vdd.n3 62.1255
R1109 Vdd.n10 Vdd.n3 62.1255
R1110 Vdd.n5 Vdd.n4 62.1255
R1111 Vdd.n4 Vdd.n2 62.1255
R1112 Vdd.n49 Vdd.n48 6.37187
R1113 Vdd.n49 Vdd.n36 6.37187
R1114 Vdd.n32 Vdd.n31 6.37187
R1115 Vdd.n32 Vdd.n19 6.37187
R1116 Vdd.n15 Vdd.n14 6.37187
R1117 Vdd.n15 Vdd.n2 6.37187
R1118 Vdd.n44 Vdd.n43 6.3005
R1119 Vdd.n40 Vdd.n39 6.3005
R1120 Vdd.n27 Vdd.n26 6.3005
R1121 Vdd.n23 Vdd.n22 6.3005
R1122 Vdd.n10 Vdd.n9 6.3005
R1123 Vdd.n6 Vdd.n5 6.3005
R1124 Vdd.n41 Vdd.n35 5.20101
R1125 Vdd.n42 Vdd.n34 5.20101
R1126 Vdd.n24 Vdd.n18 5.20101
R1127 Vdd.n25 Vdd.n17 5.20101
R1128 Vdd.n7 Vdd.n1 5.20101
R1129 Vdd.n8 Vdd.n0 5.20101
R1130 Vdd.n50 Vdd.n35 4.98321
R1131 Vdd.n33 Vdd.n18 4.98321
R1132 Vdd.n16 Vdd.n1 4.98321
R1133 Vdd.n50 Vdd.n34 4.97539
R1134 Vdd.n33 Vdd.n17 4.97539
R1135 Vdd.n16 Vdd.n0 4.97539
R1136 Vdd.n43 Vdd.n42 4.5005
R1137 Vdd.n41 Vdd.n40 4.5005
R1138 Vdd.n26 Vdd.n25 4.5005
R1139 Vdd.n24 Vdd.n23 4.5005
R1140 Vdd.n9 Vdd.n8 4.5005
R1141 Vdd.n7 Vdd.n6 4.5005
R1142 Vdd.n44 Vdd.n38 3.31679
R1143 Vdd.n39 Vdd.n38 3.31679
R1144 Vdd.n47 Vdd.n36 3.31679
R1145 Vdd.n48 Vdd.n47 3.31679
R1146 Vdd.n28 Vdd.n27 3.31679
R1147 Vdd.n28 Vdd.n22 3.31679
R1148 Vdd.n30 Vdd.n19 3.31679
R1149 Vdd.n31 Vdd.n30 3.31679
R1150 Vdd.n11 Vdd.n10 3.31679
R1151 Vdd.n11 Vdd.n5 3.31679
R1152 Vdd.n13 Vdd.n2 3.31679
R1153 Vdd.n14 Vdd.n13 3.31679
R1154 Vdd.n50 Vdd.n49 2.21557
R1155 Vdd.n33 Vdd.n32 2.21557
R1156 Vdd.n16 Vdd.n15 2.21557
R1157 Vdd.n51 Vdd.n50 2.07428
R1158 Vdd.n51 Vdd.n33 1.58034
R1159 Vdd.n52 Vdd.n16 1.58034
R1160 Vdd Vdd.n52 1.23173
R1161 Vdd.n45 Vdd.n34 0.9005
R1162 Vdd.n46 Vdd.n45 0.9005
R1163 Vdd.n37 Vdd.n35 0.9005
R1164 Vdd.n46 Vdd.n37 0.9005
R1165 Vdd.n20 Vdd.n17 0.9005
R1166 Vdd.n29 Vdd.n20 0.9005
R1167 Vdd.n21 Vdd.n18 0.9005
R1168 Vdd.n29 Vdd.n21 0.9005
R1169 Vdd.n3 Vdd.n0 0.9005
R1170 Vdd.n12 Vdd.n3 0.9005
R1171 Vdd.n4 Vdd.n1 0.9005
R1172 Vdd.n12 Vdd.n4 0.9005
R1173 Vdd.n52 Vdd.n51 0.495217
R1174 Vdd.n43 Vdd.n40 0.1445
R1175 Vdd.n42 Vdd.n41 0.1445
R1176 Vdd.n26 Vdd.n23 0.1445
R1177 Vdd.n25 Vdd.n24 0.1445
R1178 Vdd.n9 Vdd.n6 0.1445
R1179 Vdd.n8 Vdd.n7 0.1445
R1180 Iin.n472 Iin.n329 18200
R1181 Iin.n471 Iin.n470 18200
R1182 Iin.n473 Iin.n472 14238.8
R1183 Iin.n472 Iin.n471 4468.75
R1184 Iin.n471 Iin.n228 4062.5
R1185 Iin.n473 Iin.n327 229.434
R1186 Iin.n364 Iin.n363 144.525
R1187 Iin.n392 Iin.n330 144.525
R1188 Iin.n455 Iin.n454 144.525
R1189 Iin.n446 Iin.n413 144.525
R1190 Iin.n344 Iin.n332 140.912
R1191 Iin.n458 Iin.n346 140.912
R1192 Iin.n470 Iin.n469 139.106
R1193 Iin.n452 Iin.n329 131.88
R1194 Iin.n376 Iin.n375 130.072
R1195 Iin.n374 Iin.n354 130.072
R1196 Iin.n445 Iin.n414 128.267
R1197 Iin.n422 Iin.n414 122.847
R1198 Iin.n435 Iin.n429 122.847
R1199 Iin.n390 Iin.n354 121.04
R1200 Iin.n468 Iin.n332 110.201
R1201 Iin.n454 Iin.n453 102.975
R1202 Iin.n65 Iin.n57 94.2375
R1203 Iin.n74 Iin.n57 94.2375
R1204 Iin.n74 Iin.n51 94.2375
R1205 Iin.n82 Iin.n51 94.2375
R1206 Iin.n82 Iin.n45 94.2375
R1207 Iin.n90 Iin.n45 94.2375
R1208 Iin.n90 Iin.n39 94.2375
R1209 Iin.n98 Iin.n39 94.2375
R1210 Iin.n98 Iin.n32 94.2375
R1211 Iin.n107 Iin.n32 94.2375
R1212 Iin.n107 Iin.n26 94.2375
R1213 Iin.n115 Iin.n26 94.2375
R1214 Iin.n115 Iin.n20 94.2375
R1215 Iin.n127 Iin.n20 94.2375
R1216 Iin.n127 Iin.n126 94.2375
R1217 Iin.n126 Iin.n125 94.2375
R1218 Iin.n125 Iin.n10 94.2375
R1219 Iin.n587 Iin.n10 94.2375
R1220 Iin.n587 Iin.n11 94.2375
R1221 Iin.n249 Iin.n11 94.2375
R1222 Iin.n252 Iin.n249 94.2375
R1223 Iin.n253 Iin.n252 94.2375
R1224 Iin.n253 Iin.n245 94.2375
R1225 Iin.n257 Iin.n245 94.2375
R1226 Iin.n260 Iin.n257 94.2375
R1227 Iin.n261 Iin.n260 94.2375
R1228 Iin.n261 Iin.n242 94.2375
R1229 Iin.n265 Iin.n242 94.2375
R1230 Iin.n268 Iin.n265 94.2375
R1231 Iin.n269 Iin.n268 94.2375
R1232 Iin.n269 Iin.n239 94.2375
R1233 Iin.n273 Iin.n239 94.2375
R1234 Iin.n276 Iin.n273 94.2375
R1235 Iin.n277 Iin.n276 94.2375
R1236 Iin.n277 Iin.n236 94.2375
R1237 Iin.n281 Iin.n236 94.2375
R1238 Iin.n284 Iin.n281 94.2375
R1239 Iin.n285 Iin.n284 94.2375
R1240 Iin.n285 Iin.n233 94.2375
R1241 Iin.n289 Iin.n233 94.2375
R1242 Iin.n292 Iin.n289 94.2375
R1243 Iin.n293 Iin.n292 94.2375
R1244 Iin.n293 Iin.n230 94.2375
R1245 Iin.n298 Iin.n230 94.2375
R1246 Iin.n299 Iin.n298 94.2375
R1247 Iin.n363 Iin.n229 92.135
R1248 Iin.n474 Iin.n325 84.0977
R1249 Iin.n474 Iin.n326 84.0977
R1250 Iin.n64 Iin.n61 84.0977
R1251 Iin.n299 Iin.n228 74.2122
R1252 Iin.n434 Iin.n328 69.0283
R1253 Iin.n436 Iin.n328 69.0283
R1254 Iin.n444 Iin.n416 69.0283
R1255 Iin.n444 Iin.n415 69.0283
R1256 Iin.n378 Iin.n377 69.0283
R1257 Iin.n389 Iin.n355 69.0283
R1258 Iin.n378 Iin.n359 69.0283
R1259 Iin.n389 Iin.n356 69.0283
R1260 Iin.n457 Iin.n343 69.0283
R1261 Iin.n459 Iin.n343 69.0283
R1262 Iin.n467 Iin.n334 69.0283
R1263 Iin.n467 Iin.n333 69.0283
R1264 Iin.n66 Iin.n61 52.7258
R1265 Iin.n508 Iin.n229 52.3907
R1266 Iin.n453 Iin.n452 41.5514
R1267 Iin.n469 Iin.n468 34.3251
R1268 Iin.n508 Iin.n228 30.712
R1269 Iin.n392 Iin.n390 23.4858
R1270 Iin.n429 Iin.n422 21.6792
R1271 Iin.n435 Iin.n327 21.6792
R1272 Iin.n336 Iin.n335 16.6691
R1273 Iin.n446 Iin.n445 16.2595
R1274 Iin.n436 Iin.n416 15.5561
R1275 Iin.n434 Iin.n415 15.5561
R1276 Iin.n377 Iin.n355 15.5561
R1277 Iin.n359 Iin.n356 15.5561
R1278 Iin.n459 Iin.n334 15.5561
R1279 Iin.n67 Iin.n58 15.5561
R1280 Iin.n73 Iin.n58 15.5561
R1281 Iin.n73 Iin.n50 15.5561
R1282 Iin.n83 Iin.n50 15.5561
R1283 Iin.n83 Iin.n46 15.5561
R1284 Iin.n89 Iin.n46 15.5561
R1285 Iin.n89 Iin.n38 15.5561
R1286 Iin.n99 Iin.n38 15.5561
R1287 Iin.n99 Iin.n33 15.5561
R1288 Iin.n106 Iin.n33 15.5561
R1289 Iin.n106 Iin.n25 15.5561
R1290 Iin.n116 Iin.n25 15.5561
R1291 Iin.n117 Iin.n116 15.5561
R1292 Iin.n117 Iin.n21 15.5561
R1293 Iin.n123 Iin.n21 15.5561
R1294 Iin.n124 Iin.n123 15.5561
R1295 Iin.n124 Iin.n6 15.5561
R1296 Iin.n588 Iin.n6 15.5561
R1297 Iin.n588 Iin.n9 15.5561
R1298 Iin.n248 Iin.n9 15.5561
R1299 Iin.n248 Iin.n247 15.5561
R1300 Iin.n254 Iin.n247 15.5561
R1301 Iin.n255 Iin.n254 15.5561
R1302 Iin.n256 Iin.n255 15.5561
R1303 Iin.n256 Iin.n244 15.5561
R1304 Iin.n262 Iin.n244 15.5561
R1305 Iin.n263 Iin.n262 15.5561
R1306 Iin.n264 Iin.n263 15.5561
R1307 Iin.n264 Iin.n241 15.5561
R1308 Iin.n270 Iin.n241 15.5561
R1309 Iin.n271 Iin.n270 15.5561
R1310 Iin.n272 Iin.n271 15.5561
R1311 Iin.n272 Iin.n238 15.5561
R1312 Iin.n278 Iin.n238 15.5561
R1313 Iin.n279 Iin.n278 15.5561
R1314 Iin.n280 Iin.n279 15.5561
R1315 Iin.n280 Iin.n235 15.5561
R1316 Iin.n286 Iin.n235 15.5561
R1317 Iin.n287 Iin.n286 15.5561
R1318 Iin.n288 Iin.n287 15.5561
R1319 Iin.n288 Iin.n232 15.5561
R1320 Iin.n294 Iin.n232 15.5561
R1321 Iin.n296 Iin.n294 15.5561
R1322 Iin.n297 Iin.n296 15.5561
R1323 Iin.n297 Iin.n225 15.5561
R1324 Iin.n509 Iin.n225 15.5561
R1325 Iin.n509 Iin.n227 15.5561
R1326 Iin.n365 Iin.n227 15.5561
R1327 Iin.n373 Iin.n365 15.5561
R1328 Iin.n373 Iin.n353 15.5561
R1329 Iin.n393 Iin.n353 15.5561
R1330 Iin.n394 Iin.n393 15.5561
R1331 Iin.n394 Iin.n331 15.5561
R1332 Iin.n400 Iin.n331 15.5561
R1333 Iin.n401 Iin.n400 15.5561
R1334 Iin.n401 Iin.n347 15.5561
R1335 Iin.n348 Iin.n347 15.5561
R1336 Iin.n451 Iin.n348 15.5561
R1337 Iin.n451 Iin.n349 15.5561
R1338 Iin.n447 Iin.n349 15.5561
R1339 Iin.n447 Iin.n411 15.5561
R1340 Iin.n428 Iin.n411 15.5561
R1341 Iin.n428 Iin.n326 15.5561
R1342 Iin.n64 Iin.n56 15.5561
R1343 Iin.n75 Iin.n56 15.5561
R1344 Iin.n75 Iin.n52 15.5561
R1345 Iin.n81 Iin.n52 15.5561
R1346 Iin.n81 Iin.n44 15.5561
R1347 Iin.n91 Iin.n44 15.5561
R1348 Iin.n91 Iin.n40 15.5561
R1349 Iin.n97 Iin.n40 15.5561
R1350 Iin.n97 Iin.n31 15.5561
R1351 Iin.n108 Iin.n31 15.5561
R1352 Iin.n108 Iin.n27 15.5561
R1353 Iin.n114 Iin.n27 15.5561
R1354 Iin.n114 Iin.n18 15.5561
R1355 Iin.n128 Iin.n18 15.5561
R1356 Iin.n128 Iin.n19 15.5561
R1357 Iin.n19 Iin.n15 15.5561
R1358 Iin.n15 Iin.n12 15.5561
R1359 Iin.n586 Iin.n12 15.5561
R1360 Iin.n586 Iin.n13 15.5561
R1361 Iin.n250 Iin.n13 15.5561
R1362 Iin.n251 Iin.n250 15.5561
R1363 Iin.n251 Iin.n146 15.5561
R1364 Iin.n147 Iin.n146 15.5561
R1365 Iin.n258 Iin.n147 15.5561
R1366 Iin.n259 Iin.n258 15.5561
R1367 Iin.n259 Iin.n160 15.5561
R1368 Iin.n161 Iin.n160 15.5561
R1369 Iin.n266 Iin.n161 15.5561
R1370 Iin.n267 Iin.n266 15.5561
R1371 Iin.n267 Iin.n174 15.5561
R1372 Iin.n175 Iin.n174 15.5561
R1373 Iin.n274 Iin.n175 15.5561
R1374 Iin.n275 Iin.n274 15.5561
R1375 Iin.n275 Iin.n189 15.5561
R1376 Iin.n190 Iin.n189 15.5561
R1377 Iin.n282 Iin.n190 15.5561
R1378 Iin.n283 Iin.n282 15.5561
R1379 Iin.n283 Iin.n203 15.5561
R1380 Iin.n204 Iin.n203 15.5561
R1381 Iin.n290 Iin.n204 15.5561
R1382 Iin.n291 Iin.n290 15.5561
R1383 Iin.n291 Iin.n216 15.5561
R1384 Iin.n217 Iin.n216 15.5561
R1385 Iin.n218 Iin.n217 15.5561
R1386 Iin.n300 Iin.n218 15.5561
R1387 Iin.n507 Iin.n300 15.5561
R1388 Iin.n507 Iin.n301 15.5561
R1389 Iin.n305 Iin.n301 15.5561
R1390 Iin.n306 Iin.n305 15.5561
R1391 Iin.n307 Iin.n306 15.5561
R1392 Iin.n391 Iin.n307 15.5561
R1393 Iin.n391 Iin.n310 15.5561
R1394 Iin.n311 Iin.n310 15.5561
R1395 Iin.n312 Iin.n311 15.5561
R1396 Iin.n345 Iin.n312 15.5561
R1397 Iin.n345 Iin.n315 15.5561
R1398 Iin.n316 Iin.n315 15.5561
R1399 Iin.n317 Iin.n316 15.5561
R1400 Iin.n412 Iin.n317 15.5561
R1401 Iin.n412 Iin.n320 15.5561
R1402 Iin.n321 Iin.n320 15.5561
R1403 Iin.n322 Iin.n321 15.5561
R1404 Iin.n325 Iin.n322 15.5561
R1405 Iin.n376 Iin.n364 14.453
R1406 Iin.n375 Iin.n374 14.453
R1407 Iin.n413 Iin.n329 12.6464
R1408 Iin.n516 Iin.n515 12.5005
R1409 Iin.n222 Iin.n213 12.5005
R1410 Iin.n520 Iin.n214 12.5005
R1411 Iin.n210 Iin.n208 12.5005
R1412 Iin.n525 Iin.n524 12.5005
R1413 Iin.n527 Iin.n526 12.5005
R1414 Iin.n530 Iin.n201 12.5005
R1415 Iin.n196 Iin.n194 12.5005
R1416 Iin.n536 Iin.n535 12.5005
R1417 Iin.n538 Iin.n537 12.5005
R1418 Iin.n541 Iin.n187 12.5005
R1419 Iin.n182 Iin.n180 12.5005
R1420 Iin.n547 Iin.n546 12.5005
R1421 Iin.n550 Iin.n549 12.5005
R1422 Iin.n553 Iin.n172 12.5005
R1423 Iin.n167 Iin.n165 12.5005
R1424 Iin.n559 Iin.n558 12.5005
R1425 Iin.n561 Iin.n560 12.5005
R1426 Iin.n564 Iin.n158 12.5005
R1427 Iin.n153 Iin.n151 12.5005
R1428 Iin.n570 Iin.n569 12.5005
R1429 Iin.n572 Iin.n571 12.5005
R1430 Iin.n575 Iin.n144 12.5005
R1431 Iin.n139 Iin.n137 12.5005
R1432 Iin.n581 Iin.n580 12.5005
R1433 Iin.n583 Iin.n582 12.5005
R1434 Iin.n7 Iin.n3 12.5005
R1435 Iin.n592 Iin.n3 11.7031
R1436 Iin.n515 Iin.n514 11.545
R1437 Iin.n477 Iin.n0 7.89186
R1438 Iin.n140 Iin.n0 7.75378
R1439 Iin.n478 Iin.n477 7.73533
R1440 Iin.n419 Iin.n324 6.395
R1441 Iin.n582 Iin.n3 5.61588
R1442 Iin.n582 Iin.n581 5.61588
R1443 Iin.n581 Iin.n137 5.61588
R1444 Iin.n144 Iin.n137 5.61588
R1445 Iin.n571 Iin.n144 5.61588
R1446 Iin.n571 Iin.n570 5.61588
R1447 Iin.n570 Iin.n151 5.61588
R1448 Iin.n158 Iin.n151 5.61588
R1449 Iin.n560 Iin.n158 5.61588
R1450 Iin.n560 Iin.n559 5.61588
R1451 Iin.n559 Iin.n165 5.61588
R1452 Iin.n172 Iin.n165 5.61588
R1453 Iin.n549 Iin.n172 5.61588
R1454 Iin.n547 Iin.n180 5.61588
R1455 Iin.n187 Iin.n180 5.61588
R1456 Iin.n537 Iin.n187 5.61588
R1457 Iin.n537 Iin.n536 5.61588
R1458 Iin.n536 Iin.n194 5.61588
R1459 Iin.n201 Iin.n194 5.61588
R1460 Iin.n526 Iin.n201 5.61588
R1461 Iin.n526 Iin.n525 5.61588
R1462 Iin.n525 Iin.n208 5.61588
R1463 Iin.n214 Iin.n208 5.61588
R1464 Iin.n222 Iin.n214 5.61588
R1465 Iin.n515 Iin.n222 5.61588
R1466 Vss Iin.n2 5.4833
R1467 Iin.n470 Iin.n330 5.42018
R1468 Iin.n62 Iin.n60 5.35452
R1469 Iin.n69 Iin.n60 5.35452
R1470 Iin.n443 Iin.n417 5.20101
R1471 Iin.n379 Iin.n360 5.20101
R1472 Iin.n434 Iin.n433 5.2005
R1473 Iin.n435 Iin.n434 5.2005
R1474 Iin.n430 Iin.n415 5.2005
R1475 Iin.n422 Iin.n415 5.2005
R1476 Iin.n437 Iin.n436 5.2005
R1477 Iin.n436 Iin.n435 5.2005
R1478 Iin.n421 Iin.n416 5.2005
R1479 Iin.n422 Iin.n416 5.2005
R1480 Iin.n361 Iin.n355 5.2005
R1481 Iin.n374 Iin.n355 5.2005
R1482 Iin.n377 Iin.n362 5.2005
R1483 Iin.n377 Iin.n376 5.2005
R1484 Iin.n385 Iin.n356 5.2005
R1485 Iin.n374 Iin.n356 5.2005
R1486 Iin.n384 Iin.n359 5.2005
R1487 Iin.n376 Iin.n359 5.2005
R1488 Iin.n460 Iin.n459 5.2005
R1489 Iin.n459 Iin.n458 5.2005
R1490 Iin.n341 Iin.n334 5.2005
R1491 Iin.n344 Iin.n334 5.2005
R1492 Iin.n458 Iin.n457 5.2005
R1493 Iin.n344 Iin.n333 5.2005
R1494 Iin.n426 Iin.n326 5.2005
R1495 Iin.n327 Iin.n326 5.2005
R1496 Iin.n428 Iin.n427 5.2005
R1497 Iin.n429 Iin.n428 5.2005
R1498 Iin.n411 Iin.n410 5.2005
R1499 Iin.n414 Iin.n411 5.2005
R1500 Iin.n448 Iin.n447 5.2005
R1501 Iin.n447 Iin.n446 5.2005
R1502 Iin.n449 Iin.n349 5.2005
R1503 Iin.n413 Iin.n349 5.2005
R1504 Iin.n451 Iin.n450 5.2005
R1505 Iin.n452 Iin.n451 5.2005
R1506 Iin.n405 Iin.n348 5.2005
R1507 Iin.n454 Iin.n348 5.2005
R1508 Iin.n404 Iin.n347 5.2005
R1509 Iin.n455 Iin.n347 5.2005
R1510 Iin.n402 Iin.n401 5.2005
R1511 Iin.n401 Iin.n346 5.2005
R1512 Iin.n400 Iin.n399 5.2005
R1513 Iin.n400 Iin.n332 5.2005
R1514 Iin.n350 Iin.n331 5.2005
R1515 Iin.n469 Iin.n331 5.2005
R1516 Iin.n395 Iin.n394 5.2005
R1517 Iin.n394 Iin.n330 5.2005
R1518 Iin.n393 Iin.n352 5.2005
R1519 Iin.n393 Iin.n392 5.2005
R1520 Iin.n371 Iin.n353 5.2005
R1521 Iin.n354 Iin.n353 5.2005
R1522 Iin.n373 Iin.n372 5.2005
R1523 Iin.n375 Iin.n373 5.2005
R1524 Iin.n366 Iin.n365 5.2005
R1525 Iin.n365 Iin.n364 5.2005
R1526 Iin.n227 Iin.n226 5.2005
R1527 Iin.n363 Iin.n227 5.2005
R1528 Iin.n510 Iin.n509 5.2005
R1529 Iin.n509 Iin.n508 5.2005
R1530 Iin.n511 Iin.n225 5.2005
R1531 Iin.n299 Iin.n225 5.2005
R1532 Iin.n297 Iin.n220 5.2005
R1533 Iin.n298 Iin.n297 5.2005
R1534 Iin.n296 Iin.n295 5.2005
R1535 Iin.n296 Iin.n230 5.2005
R1536 Iin.n294 Iin.n212 5.2005
R1537 Iin.n294 Iin.n293 5.2005
R1538 Iin.n232 Iin.n231 5.2005
R1539 Iin.n292 Iin.n232 5.2005
R1540 Iin.n288 Iin.n209 5.2005
R1541 Iin.n289 Iin.n288 5.2005
R1542 Iin.n287 Iin.n206 5.2005
R1543 Iin.n287 Iin.n233 5.2005
R1544 Iin.n286 Iin.n199 5.2005
R1545 Iin.n286 Iin.n285 5.2005
R1546 Iin.n235 Iin.n234 5.2005
R1547 Iin.n284 Iin.n235 5.2005
R1548 Iin.n280 Iin.n195 5.2005
R1549 Iin.n281 Iin.n280 5.2005
R1550 Iin.n279 Iin.n192 5.2005
R1551 Iin.n279 Iin.n236 5.2005
R1552 Iin.n278 Iin.n185 5.2005
R1553 Iin.n278 Iin.n277 5.2005
R1554 Iin.n238 Iin.n237 5.2005
R1555 Iin.n276 Iin.n238 5.2005
R1556 Iin.n272 Iin.n181 5.2005
R1557 Iin.n273 Iin.n272 5.2005
R1558 Iin.n271 Iin.n177 5.2005
R1559 Iin.n271 Iin.n239 5.2005
R1560 Iin.n270 Iin.n170 5.2005
R1561 Iin.n270 Iin.n269 5.2005
R1562 Iin.n241 Iin.n240 5.2005
R1563 Iin.n268 Iin.n241 5.2005
R1564 Iin.n264 Iin.n166 5.2005
R1565 Iin.n265 Iin.n264 5.2005
R1566 Iin.n263 Iin.n163 5.2005
R1567 Iin.n263 Iin.n242 5.2005
R1568 Iin.n262 Iin.n156 5.2005
R1569 Iin.n262 Iin.n261 5.2005
R1570 Iin.n244 Iin.n243 5.2005
R1571 Iin.n260 Iin.n244 5.2005
R1572 Iin.n256 Iin.n152 5.2005
R1573 Iin.n257 Iin.n256 5.2005
R1574 Iin.n255 Iin.n149 5.2005
R1575 Iin.n255 Iin.n245 5.2005
R1576 Iin.n254 Iin.n142 5.2005
R1577 Iin.n254 Iin.n253 5.2005
R1578 Iin.n247 Iin.n246 5.2005
R1579 Iin.n252 Iin.n247 5.2005
R1580 Iin.n248 Iin.n138 5.2005
R1581 Iin.n249 Iin.n248 5.2005
R1582 Iin.n9 Iin.n8 5.2005
R1583 Iin.n11 Iin.n9 5.2005
R1584 Iin.n589 Iin.n588 5.2005
R1585 Iin.n588 Iin.n587 5.2005
R1586 Iin.n590 Iin.n6 5.2005
R1587 Iin.n10 Iin.n6 5.2005
R1588 Iin.n124 Iin.n5 5.2005
R1589 Iin.n125 Iin.n124 5.2005
R1590 Iin.n123 Iin.n122 5.2005
R1591 Iin.n126 Iin.n123 5.2005
R1592 Iin.n22 Iin.n21 5.2005
R1593 Iin.n127 Iin.n21 5.2005
R1594 Iin.n118 Iin.n117 5.2005
R1595 Iin.n117 Iin.n20 5.2005
R1596 Iin.n116 Iin.n24 5.2005
R1597 Iin.n116 Iin.n115 5.2005
R1598 Iin.n35 Iin.n25 5.2005
R1599 Iin.n26 Iin.n25 5.2005
R1600 Iin.n106 Iin.n105 5.2005
R1601 Iin.n107 Iin.n106 5.2005
R1602 Iin.n34 Iin.n33 5.2005
R1603 Iin.n33 Iin.n32 5.2005
R1604 Iin.n100 Iin.n99 5.2005
R1605 Iin.n99 Iin.n98 5.2005
R1606 Iin.n38 Iin.n37 5.2005
R1607 Iin.n39 Iin.n38 5.2005
R1608 Iin.n89 Iin.n88 5.2005
R1609 Iin.n90 Iin.n89 5.2005
R1610 Iin.n47 Iin.n46 5.2005
R1611 Iin.n46 Iin.n45 5.2005
R1612 Iin.n84 Iin.n83 5.2005
R1613 Iin.n83 Iin.n82 5.2005
R1614 Iin.n50 Iin.n49 5.2005
R1615 Iin.n51 Iin.n50 5.2005
R1616 Iin.n73 Iin.n72 5.2005
R1617 Iin.n74 Iin.n73 5.2005
R1618 Iin.n59 Iin.n58 5.2005
R1619 Iin.n58 Iin.n57 5.2005
R1620 Iin.n68 Iin.n67 5.2005
R1621 Iin.n325 Iin.n323 5.2005
R1622 Iin.n327 Iin.n325 5.2005
R1623 Iin.n482 Iin.n322 5.2005
R1624 Iin.n429 Iin.n322 5.2005
R1625 Iin.n483 Iin.n321 5.2005
R1626 Iin.n414 Iin.n321 5.2005
R1627 Iin.n484 Iin.n320 5.2005
R1628 Iin.n446 Iin.n320 5.2005
R1629 Iin.n412 Iin.n318 5.2005
R1630 Iin.n413 Iin.n412 5.2005
R1631 Iin.n488 Iin.n317 5.2005
R1632 Iin.n452 Iin.n317 5.2005
R1633 Iin.n489 Iin.n316 5.2005
R1634 Iin.n454 Iin.n316 5.2005
R1635 Iin.n490 Iin.n315 5.2005
R1636 Iin.n455 Iin.n315 5.2005
R1637 Iin.n345 Iin.n313 5.2005
R1638 Iin.n346 Iin.n345 5.2005
R1639 Iin.n494 Iin.n312 5.2005
R1640 Iin.n332 Iin.n312 5.2005
R1641 Iin.n495 Iin.n311 5.2005
R1642 Iin.n469 Iin.n311 5.2005
R1643 Iin.n496 Iin.n310 5.2005
R1644 Iin.n330 Iin.n310 5.2005
R1645 Iin.n391 Iin.n308 5.2005
R1646 Iin.n392 Iin.n391 5.2005
R1647 Iin.n500 Iin.n307 5.2005
R1648 Iin.n354 Iin.n307 5.2005
R1649 Iin.n501 Iin.n306 5.2005
R1650 Iin.n375 Iin.n306 5.2005
R1651 Iin.n502 Iin.n305 5.2005
R1652 Iin.n364 Iin.n305 5.2005
R1653 Iin.n302 Iin.n301 5.2005
R1654 Iin.n363 Iin.n301 5.2005
R1655 Iin.n507 Iin.n506 5.2005
R1656 Iin.n508 Iin.n507 5.2005
R1657 Iin.n300 Iin.n219 5.2005
R1658 Iin.n300 Iin.n299 5.2005
R1659 Iin.n517 Iin.n218 5.2005
R1660 Iin.n298 Iin.n218 5.2005
R1661 Iin.n518 Iin.n217 5.2005
R1662 Iin.n230 Iin.n217 5.2005
R1663 Iin.n519 Iin.n216 5.2005
R1664 Iin.n293 Iin.n216 5.2005
R1665 Iin.n291 Iin.n215 5.2005
R1666 Iin.n292 Iin.n291 5.2005
R1667 Iin.n290 Iin.n205 5.2005
R1668 Iin.n290 Iin.n289 5.2005
R1669 Iin.n528 Iin.n204 5.2005
R1670 Iin.n233 Iin.n204 5.2005
R1671 Iin.n529 Iin.n203 5.2005
R1672 Iin.n285 Iin.n203 5.2005
R1673 Iin.n283 Iin.n202 5.2005
R1674 Iin.n284 Iin.n283 5.2005
R1675 Iin.n282 Iin.n191 5.2005
R1676 Iin.n282 Iin.n281 5.2005
R1677 Iin.n539 Iin.n190 5.2005
R1678 Iin.n236 Iin.n190 5.2005
R1679 Iin.n540 Iin.n189 5.2005
R1680 Iin.n277 Iin.n189 5.2005
R1681 Iin.n275 Iin.n188 5.2005
R1682 Iin.n276 Iin.n275 5.2005
R1683 Iin.n274 Iin.n176 5.2005
R1684 Iin.n274 Iin.n273 5.2005
R1685 Iin.n551 Iin.n175 5.2005
R1686 Iin.n239 Iin.n175 5.2005
R1687 Iin.n552 Iin.n174 5.2005
R1688 Iin.n269 Iin.n174 5.2005
R1689 Iin.n267 Iin.n173 5.2005
R1690 Iin.n268 Iin.n267 5.2005
R1691 Iin.n266 Iin.n162 5.2005
R1692 Iin.n266 Iin.n265 5.2005
R1693 Iin.n562 Iin.n161 5.2005
R1694 Iin.n242 Iin.n161 5.2005
R1695 Iin.n563 Iin.n160 5.2005
R1696 Iin.n261 Iin.n160 5.2005
R1697 Iin.n259 Iin.n159 5.2005
R1698 Iin.n260 Iin.n259 5.2005
R1699 Iin.n258 Iin.n148 5.2005
R1700 Iin.n258 Iin.n257 5.2005
R1701 Iin.n573 Iin.n147 5.2005
R1702 Iin.n245 Iin.n147 5.2005
R1703 Iin.n574 Iin.n146 5.2005
R1704 Iin.n253 Iin.n146 5.2005
R1705 Iin.n251 Iin.n145 5.2005
R1706 Iin.n252 Iin.n251 5.2005
R1707 Iin.n250 Iin.n135 5.2005
R1708 Iin.n250 Iin.n249 5.2005
R1709 Iin.n584 Iin.n13 5.2005
R1710 Iin.n13 Iin.n11 5.2005
R1711 Iin.n586 Iin.n585 5.2005
R1712 Iin.n587 Iin.n586 5.2005
R1713 Iin.n134 Iin.n12 5.2005
R1714 Iin.n12 Iin.n10 5.2005
R1715 Iin.n133 Iin.n15 5.2005
R1716 Iin.n125 Iin.n15 5.2005
R1717 Iin.n19 Iin.n14 5.2005
R1718 Iin.n126 Iin.n19 5.2005
R1719 Iin.n129 Iin.n128 5.2005
R1720 Iin.n128 Iin.n127 5.2005
R1721 Iin.n18 Iin.n17 5.2005
R1722 Iin.n20 Iin.n18 5.2005
R1723 Iin.n114 Iin.n113 5.2005
R1724 Iin.n115 Iin.n114 5.2005
R1725 Iin.n28 Iin.n27 5.2005
R1726 Iin.n27 Iin.n26 5.2005
R1727 Iin.n109 Iin.n108 5.2005
R1728 Iin.n108 Iin.n107 5.2005
R1729 Iin.n31 Iin.n30 5.2005
R1730 Iin.n32 Iin.n31 5.2005
R1731 Iin.n97 Iin.n96 5.2005
R1732 Iin.n98 Iin.n97 5.2005
R1733 Iin.n41 Iin.n40 5.2005
R1734 Iin.n40 Iin.n39 5.2005
R1735 Iin.n92 Iin.n91 5.2005
R1736 Iin.n91 Iin.n90 5.2005
R1737 Iin.n44 Iin.n43 5.2005
R1738 Iin.n45 Iin.n44 5.2005
R1739 Iin.n81 Iin.n80 5.2005
R1740 Iin.n82 Iin.n81 5.2005
R1741 Iin.n53 Iin.n52 5.2005
R1742 Iin.n52 Iin.n51 5.2005
R1743 Iin.n76 Iin.n75 5.2005
R1744 Iin.n75 Iin.n74 5.2005
R1745 Iin.n56 Iin.n55 5.2005
R1746 Iin.n57 Iin.n56 5.2005
R1747 Iin.n64 Iin.n63 5.2005
R1748 Iin.n65 Iin.n64 5.2005
R1749 Iin.n432 Iin.n431 5.19319
R1750 Iin.n388 Iin.n357 5.19319
R1751 Iin.n475 Iin.n324 5.12952
R1752 Iin.n466 Iin.n336 5.12001
R1753 Iin.n342 Iin.n336 5.11219
R1754 Iin.n480 Iin.n479 5.04833
R1755 Iin.n431 Iin.n420 5.00286
R1756 Iin.n382 Iin.n379 5.00286
R1757 Iin.n466 Iin.n465 5.00286
R1758 Iin.n443 Iin.n442 5.00286
R1759 Iin.n388 Iin.n387 5.00286
R1760 Iin.n342 Iin.n340 5.00286
R1761 Iin.n479 Iin.n478 4.7183
R1762 Iin.n512 Iin.n511 4.5005
R1763 Iin.n510 Iin.n224 4.5005
R1764 Iin.n367 Iin.n226 4.5005
R1765 Iin.n368 Iin.n366 4.5005
R1766 Iin.n372 Iin.n369 4.5005
R1767 Iin.n371 Iin.n370 4.5005
R1768 Iin.n352 Iin.n351 4.5005
R1769 Iin.n396 Iin.n395 4.5005
R1770 Iin.n397 Iin.n350 4.5005
R1771 Iin.n399 Iin.n398 4.5005
R1772 Iin.n589 Iin.n7 4.5005
R1773 Iin.n583 Iin.n8 4.5005
R1774 Iin.n580 Iin.n138 4.5005
R1775 Iin.n246 Iin.n139 4.5005
R1776 Iin.n575 Iin.n142 4.5005
R1777 Iin.n572 Iin.n149 4.5005
R1778 Iin.n569 Iin.n152 4.5005
R1779 Iin.n243 Iin.n153 4.5005
R1780 Iin.n564 Iin.n156 4.5005
R1781 Iin.n561 Iin.n163 4.5005
R1782 Iin.n558 Iin.n166 4.5005
R1783 Iin.n240 Iin.n167 4.5005
R1784 Iin.n553 Iin.n170 4.5005
R1785 Iin.n550 Iin.n177 4.5005
R1786 Iin.n546 Iin.n181 4.5005
R1787 Iin.n237 Iin.n182 4.5005
R1788 Iin.n541 Iin.n185 4.5005
R1789 Iin.n538 Iin.n192 4.5005
R1790 Iin.n535 Iin.n195 4.5005
R1791 Iin.n234 Iin.n196 4.5005
R1792 Iin.n530 Iin.n199 4.5005
R1793 Iin.n527 Iin.n206 4.5005
R1794 Iin.n524 Iin.n209 4.5005
R1795 Iin.n231 Iin.n210 4.5005
R1796 Iin.n520 Iin.n212 4.5005
R1797 Iin.n295 Iin.n213 4.5005
R1798 Iin.n516 Iin.n220 4.5005
R1799 Iin.n438 Iin.n437 4.5005
R1800 Iin.n421 Iin.n418 4.5005
R1801 Iin.n433 Iin.n432 4.5005
R1802 Iin.n430 Iin.n417 4.5005
R1803 Iin.n361 Iin.n357 4.5005
R1804 Iin.n362 Iin.n360 4.5005
R1805 Iin.n386 Iin.n385 4.5005
R1806 Iin.n384 Iin.n383 4.5005
R1807 Iin.n387 Iin.n338 4.5005
R1808 Iin.n380 Iin.n358 4.5005
R1809 Iin.n382 Iin.n381 4.5005
R1810 Iin.n420 Iin.n419 4.5005
R1811 Iin.n440 Iin.n439 4.5005
R1812 Iin.n442 Iin.n441 4.5005
R1813 Iin.n340 Iin.n339 4.5005
R1814 Iin.n463 Iin.n462 4.5005
R1815 Iin.n465 Iin.n464 4.5005
R1816 Iin.n461 Iin.n460 4.5005
R1817 Iin.n341 Iin.n337 4.5005
R1818 Iin.n406 Iin.n405 4.5005
R1819 Iin.n450 Iin.n407 4.5005
R1820 Iin.n449 Iin.n408 4.5005
R1821 Iin.n448 Iin.n409 4.5005
R1822 Iin.n423 Iin.n410 4.5005
R1823 Iin.n427 Iin.n424 4.5005
R1824 Iin.n426 Iin.n425 4.5005
R1825 Iin.n585 Iin.n7 4.5005
R1826 Iin.n584 Iin.n583 4.5005
R1827 Iin.n580 Iin.n135 4.5005
R1828 Iin.n145 Iin.n139 4.5005
R1829 Iin.n575 Iin.n574 4.5005
R1830 Iin.n573 Iin.n572 4.5005
R1831 Iin.n569 Iin.n148 4.5005
R1832 Iin.n159 Iin.n153 4.5005
R1833 Iin.n564 Iin.n563 4.5005
R1834 Iin.n562 Iin.n561 4.5005
R1835 Iin.n558 Iin.n162 4.5005
R1836 Iin.n173 Iin.n167 4.5005
R1837 Iin.n553 Iin.n552 4.5005
R1838 Iin.n551 Iin.n550 4.5005
R1839 Iin.n546 Iin.n176 4.5005
R1840 Iin.n188 Iin.n182 4.5005
R1841 Iin.n541 Iin.n540 4.5005
R1842 Iin.n539 Iin.n538 4.5005
R1843 Iin.n535 Iin.n191 4.5005
R1844 Iin.n202 Iin.n196 4.5005
R1845 Iin.n530 Iin.n529 4.5005
R1846 Iin.n528 Iin.n527 4.5005
R1847 Iin.n524 Iin.n205 4.5005
R1848 Iin.n215 Iin.n210 4.5005
R1849 Iin.n520 Iin.n519 4.5005
R1850 Iin.n518 Iin.n213 4.5005
R1851 Iin.n517 Iin.n516 4.5005
R1852 Iin.n303 Iin.n219 4.5005
R1853 Iin.n506 Iin.n505 4.5005
R1854 Iin.n504 Iin.n302 4.5005
R1855 Iin.n503 Iin.n502 4.5005
R1856 Iin.n501 Iin.n304 4.5005
R1857 Iin.n500 Iin.n499 4.5005
R1858 Iin.n498 Iin.n308 4.5005
R1859 Iin.n497 Iin.n496 4.5005
R1860 Iin.n495 Iin.n309 4.5005
R1861 Iin.n494 Iin.n493 4.5005
R1862 Iin.n492 Iin.n313 4.5005
R1863 Iin.n491 Iin.n490 4.5005
R1864 Iin.n489 Iin.n314 4.5005
R1865 Iin.n488 Iin.n487 4.5005
R1866 Iin.n486 Iin.n318 4.5005
R1867 Iin.n485 Iin.n484 4.5005
R1868 Iin.n483 Iin.n319 4.5005
R1869 Iin.n482 Iin.n481 4.5005
R1870 Iin.n480 Iin.n323 4.5005
R1871 Iin.n55 Iin.n54 4.5005
R1872 Iin.n77 Iin.n76 4.5005
R1873 Iin.n78 Iin.n53 4.5005
R1874 Iin.n80 Iin.n79 4.5005
R1875 Iin.n43 Iin.n42 4.5005
R1876 Iin.n93 Iin.n92 4.5005
R1877 Iin.n94 Iin.n41 4.5005
R1878 Iin.n96 Iin.n95 4.5005
R1879 Iin.n30 Iin.n29 4.5005
R1880 Iin.n110 Iin.n109 4.5005
R1881 Iin.n111 Iin.n28 4.5005
R1882 Iin.n113 Iin.n112 4.5005
R1883 Iin.n17 Iin.n16 4.5005
R1884 Iin.n130 Iin.n129 4.5005
R1885 Iin.n131 Iin.n14 4.5005
R1886 Iin.n133 Iin.n132 4.5005
R1887 Iin.n134 Iin.n1 4.5005
R1888 Iin.n63 Iin.n62 4.5005
R1889 Iin.n70 Iin.n59 4.5005
R1890 Iin.n72 Iin.n71 4.5005
R1891 Iin.n49 Iin.n48 4.5005
R1892 Iin.n85 Iin.n84 4.5005
R1893 Iin.n86 Iin.n47 4.5005
R1894 Iin.n88 Iin.n87 4.5005
R1895 Iin.n37 Iin.n36 4.5005
R1896 Iin.n101 Iin.n100 4.5005
R1897 Iin.n102 Iin.n34 4.5005
R1898 Iin.n105 Iin.n104 4.5005
R1899 Iin.n103 Iin.n35 4.5005
R1900 Iin.n24 Iin.n23 4.5005
R1901 Iin.n119 Iin.n118 4.5005
R1902 Iin.n120 Iin.n22 4.5005
R1903 Iin.n122 Iin.n121 4.5005
R1904 Iin.n5 Iin.n4 4.5005
R1905 Iin.n591 Iin.n590 4.5005
R1906 Iin.n69 Iin.n68 4.5005
R1907 Iin.n596 Iin.n595 4.5005
R1908 Iin.n346 Iin.n344 3.61362
R1909 Iin.n458 Iin.n455 3.61362
R1910 Iin.n456 Iin.n336 3.28078
R1911 Iin.n66 Iin.n65 3.26114
R1912 Iin.n456 Iin.n333 3.14293
R1913 Iin.n457 Iin.n456 3.14293
R1914 Iin.n549 Iin.n548 2.80819
R1915 Iin.n548 Iin.n547 2.80819
R1916 Iin.n478 Iin.n476 2.6735
R1917 Iin.n403 Iin.n223 2.21557
R1918 Iin.n595 Iin.n594 2.1983
R1919 Iin.n67 Iin.n66 1.82789
R1920 Iin.n514 Iin.n223 1.23277
R1921 Iin.n381 Vss 1.1597
R1922 Iin.n444 Iin.n443 0.743357
R1923 Iin.n445 Iin.n444 0.743357
R1924 Iin.n431 Iin.n328 0.743357
R1925 Iin.n473 Iin.n328 0.743357
R1926 Iin.n389 Iin.n388 0.743357
R1927 Iin.n390 Iin.n389 0.743357
R1928 Iin.n379 Iin.n378 0.743357
R1929 Iin.n378 Iin.n229 0.743357
R1930 Iin.n343 Iin.n342 0.743357
R1931 Iin.n453 Iin.n343 0.743357
R1932 Iin.n467 Iin.n466 0.743357
R1933 Iin.n468 Iin.n467 0.743357
R1934 Iin.n594 Iin.n593 0.573125
R1935 Iin.n513 Iin.n221 0.483125
R1936 Iin.n593 Iin.n592 0.483125
R1937 Iin.n475 Iin.n474 0.473227
R1938 Iin.n474 Iin.n473 0.473227
R1939 Iin.n61 Iin.n60 0.473227
R1940 Iin.n476 Iin.n303 0.44735
R1941 Iin.n476 Iin.n221 0.393125
R1942 Iin.n464 Iin.n338 0.3515
R1943 Iin.n441 Iin.n339 0.3515
R1944 Iin.n479 Iin.n475 0.29887
R1945 Iin.n522 Iin.n521 0.28625
R1946 Iin.n523 Iin.n522 0.28175
R1947 Iin.n211 Iin.n207 0.28175
R1948 Iin.n200 Iin.n198 0.28175
R1949 Iin.n532 Iin.n531 0.28175
R1950 Iin.n534 Iin.n533 0.28175
R1951 Iin.n197 Iin.n193 0.28175
R1952 Iin.n186 Iin.n184 0.28175
R1953 Iin.n543 Iin.n542 0.28175
R1954 Iin.n545 Iin.n544 0.28175
R1955 Iin.n183 Iin.n178 0.28175
R1956 Iin.n171 Iin.n169 0.28175
R1957 Iin.n555 Iin.n554 0.28175
R1958 Iin.n557 Iin.n556 0.28175
R1959 Iin.n168 Iin.n164 0.28175
R1960 Iin.n157 Iin.n155 0.28175
R1961 Iin.n566 Iin.n565 0.28175
R1962 Iin.n568 Iin.n567 0.28175
R1963 Iin.n154 Iin.n150 0.28175
R1964 Iin.n143 Iin.n141 0.28175
R1965 Iin.n577 Iin.n576 0.28175
R1966 Iin.n579 Iin.n578 0.28175
R1967 Iin.n140 Iin.n136 0.28175
R1968 Iin.n595 Iin.n0 0.2705
R1969 Iin.n513 Iin.n512 0.26735
R1970 Iin.n425 Iin.n324 0.2255
R1971 Iin.n514 Iin.n513 0.219838
R1972 Iin.n594 Iin.n1 0.20615
R1973 Iin.n592 Iin.n591 0.20615
R1974 Iin.n548 Iin.n179 0.1684
R1975 Iin.n460 Iin.n341 0.1445
R1976 Iin.n68 Iin.n59 0.1445
R1977 Iin.n72 Iin.n59 0.1445
R1978 Iin.n72 Iin.n49 0.1445
R1979 Iin.n84 Iin.n49 0.1445
R1980 Iin.n84 Iin.n47 0.1445
R1981 Iin.n88 Iin.n47 0.1445
R1982 Iin.n88 Iin.n37 0.1445
R1983 Iin.n100 Iin.n37 0.1445
R1984 Iin.n100 Iin.n34 0.1445
R1985 Iin.n105 Iin.n34 0.1445
R1986 Iin.n105 Iin.n35 0.1445
R1987 Iin.n35 Iin.n24 0.1445
R1988 Iin.n118 Iin.n24 0.1445
R1989 Iin.n118 Iin.n22 0.1445
R1990 Iin.n122 Iin.n22 0.1445
R1991 Iin.n122 Iin.n5 0.1445
R1992 Iin.n590 Iin.n5 0.1445
R1993 Iin.n590 Iin.n589 0.1445
R1994 Iin.n589 Iin.n8 0.1445
R1995 Iin.n138 Iin.n8 0.1445
R1996 Iin.n246 Iin.n138 0.1445
R1997 Iin.n246 Iin.n142 0.1445
R1998 Iin.n149 Iin.n142 0.1445
R1999 Iin.n152 Iin.n149 0.1445
R2000 Iin.n243 Iin.n152 0.1445
R2001 Iin.n243 Iin.n156 0.1445
R2002 Iin.n163 Iin.n156 0.1445
R2003 Iin.n166 Iin.n163 0.1445
R2004 Iin.n240 Iin.n166 0.1445
R2005 Iin.n240 Iin.n170 0.1445
R2006 Iin.n177 Iin.n170 0.1445
R2007 Iin.n181 Iin.n177 0.1445
R2008 Iin.n237 Iin.n181 0.1445
R2009 Iin.n237 Iin.n185 0.1445
R2010 Iin.n192 Iin.n185 0.1445
R2011 Iin.n195 Iin.n192 0.1445
R2012 Iin.n234 Iin.n195 0.1445
R2013 Iin.n234 Iin.n199 0.1445
R2014 Iin.n206 Iin.n199 0.1445
R2015 Iin.n209 Iin.n206 0.1445
R2016 Iin.n231 Iin.n209 0.1445
R2017 Iin.n231 Iin.n212 0.1445
R2018 Iin.n295 Iin.n212 0.1445
R2019 Iin.n295 Iin.n220 0.1445
R2020 Iin.n511 Iin.n220 0.1445
R2021 Iin.n511 Iin.n510 0.1445
R2022 Iin.n510 Iin.n226 0.1445
R2023 Iin.n366 Iin.n226 0.1445
R2024 Iin.n372 Iin.n366 0.1445
R2025 Iin.n372 Iin.n371 0.1445
R2026 Iin.n371 Iin.n352 0.1445
R2027 Iin.n395 Iin.n352 0.1445
R2028 Iin.n395 Iin.n350 0.1445
R2029 Iin.n399 Iin.n350 0.1445
R2030 Iin.n402 Iin.n399 0.1445
R2031 Iin.n405 Iin.n404 0.1445
R2032 Iin.n450 Iin.n405 0.1445
R2033 Iin.n450 Iin.n449 0.1445
R2034 Iin.n449 Iin.n448 0.1445
R2035 Iin.n448 Iin.n410 0.1445
R2036 Iin.n427 Iin.n410 0.1445
R2037 Iin.n427 Iin.n426 0.1445
R2038 Iin.n512 Iin.n224 0.1445
R2039 Iin.n367 Iin.n224 0.1445
R2040 Iin.n368 Iin.n367 0.1445
R2041 Iin.n369 Iin.n368 0.1445
R2042 Iin.n370 Iin.n369 0.1445
R2043 Iin.n370 Iin.n351 0.1445
R2044 Iin.n396 Iin.n351 0.1445
R2045 Iin.n397 Iin.n396 0.1445
R2046 Iin.n398 Iin.n397 0.1445
R2047 Iin.n505 Iin.n303 0.1445
R2048 Iin.n505 Iin.n504 0.1445
R2049 Iin.n504 Iin.n503 0.1445
R2050 Iin.n503 Iin.n304 0.1445
R2051 Iin.n499 Iin.n304 0.1445
R2052 Iin.n499 Iin.n498 0.1445
R2053 Iin.n498 Iin.n497 0.1445
R2054 Iin.n497 Iin.n309 0.1445
R2055 Iin.n493 Iin.n309 0.1445
R2056 Iin.n493 Iin.n492 0.1445
R2057 Iin.n492 Iin.n491 0.1445
R2058 Iin.n491 Iin.n314 0.1445
R2059 Iin.n487 Iin.n314 0.1445
R2060 Iin.n487 Iin.n486 0.1445
R2061 Iin.n486 Iin.n485 0.1445
R2062 Iin.n485 Iin.n319 0.1445
R2063 Iin.n481 Iin.n319 0.1445
R2064 Iin.n481 Iin.n480 0.1445
R2065 Iin.n385 Iin.n384 0.1445
R2066 Iin.n437 Iin.n421 0.1445
R2067 Iin.n432 Iin.n417 0.1445
R2068 Iin.n433 Iin.n430 0.1445
R2069 Iin.n362 Iin.n361 0.1445
R2070 Iin.n360 Iin.n357 0.1445
R2071 Iin.n407 Iin.n406 0.1445
R2072 Iin.n408 Iin.n407 0.1445
R2073 Iin.n409 Iin.n408 0.1445
R2074 Iin.n423 Iin.n409 0.1445
R2075 Iin.n424 Iin.n423 0.1445
R2076 Iin.n425 Iin.n424 0.1445
R2077 Iin.n63 Iin.n55 0.1445
R2078 Iin.n76 Iin.n55 0.1445
R2079 Iin.n76 Iin.n53 0.1445
R2080 Iin.n80 Iin.n53 0.1445
R2081 Iin.n80 Iin.n43 0.1445
R2082 Iin.n92 Iin.n43 0.1445
R2083 Iin.n92 Iin.n41 0.1445
R2084 Iin.n96 Iin.n41 0.1445
R2085 Iin.n96 Iin.n30 0.1445
R2086 Iin.n109 Iin.n30 0.1445
R2087 Iin.n109 Iin.n28 0.1445
R2088 Iin.n113 Iin.n28 0.1445
R2089 Iin.n113 Iin.n17 0.1445
R2090 Iin.n129 Iin.n17 0.1445
R2091 Iin.n129 Iin.n14 0.1445
R2092 Iin.n133 Iin.n14 0.1445
R2093 Iin.n134 Iin.n133 0.1445
R2094 Iin.n585 Iin.n134 0.1445
R2095 Iin.n585 Iin.n584 0.1445
R2096 Iin.n584 Iin.n135 0.1445
R2097 Iin.n145 Iin.n135 0.1445
R2098 Iin.n574 Iin.n145 0.1445
R2099 Iin.n574 Iin.n573 0.1445
R2100 Iin.n573 Iin.n148 0.1445
R2101 Iin.n159 Iin.n148 0.1445
R2102 Iin.n563 Iin.n159 0.1445
R2103 Iin.n563 Iin.n562 0.1445
R2104 Iin.n562 Iin.n162 0.1445
R2105 Iin.n173 Iin.n162 0.1445
R2106 Iin.n552 Iin.n173 0.1445
R2107 Iin.n552 Iin.n551 0.1445
R2108 Iin.n551 Iin.n176 0.1445
R2109 Iin.n188 Iin.n176 0.1445
R2110 Iin.n540 Iin.n188 0.1445
R2111 Iin.n540 Iin.n539 0.1445
R2112 Iin.n539 Iin.n191 0.1445
R2113 Iin.n202 Iin.n191 0.1445
R2114 Iin.n529 Iin.n202 0.1445
R2115 Iin.n529 Iin.n528 0.1445
R2116 Iin.n528 Iin.n205 0.1445
R2117 Iin.n215 Iin.n205 0.1445
R2118 Iin.n519 Iin.n215 0.1445
R2119 Iin.n519 Iin.n518 0.1445
R2120 Iin.n518 Iin.n517 0.1445
R2121 Iin.n517 Iin.n219 0.1445
R2122 Iin.n506 Iin.n219 0.1445
R2123 Iin.n506 Iin.n302 0.1445
R2124 Iin.n502 Iin.n302 0.1445
R2125 Iin.n502 Iin.n501 0.1445
R2126 Iin.n501 Iin.n500 0.1445
R2127 Iin.n500 Iin.n308 0.1445
R2128 Iin.n496 Iin.n308 0.1445
R2129 Iin.n496 Iin.n495 0.1445
R2130 Iin.n495 Iin.n494 0.1445
R2131 Iin.n494 Iin.n313 0.1445
R2132 Iin.n490 Iin.n313 0.1445
R2133 Iin.n490 Iin.n489 0.1445
R2134 Iin.n489 Iin.n488 0.1445
R2135 Iin.n488 Iin.n318 0.1445
R2136 Iin.n484 Iin.n318 0.1445
R2137 Iin.n484 Iin.n483 0.1445
R2138 Iin.n483 Iin.n482 0.1445
R2139 Iin.n482 Iin.n323 0.1445
R2140 Iin.n62 Iin.n54 0.1445
R2141 Iin.n77 Iin.n54 0.1445
R2142 Iin.n78 Iin.n77 0.1445
R2143 Iin.n79 Iin.n78 0.1445
R2144 Iin.n79 Iin.n42 0.1445
R2145 Iin.n93 Iin.n42 0.1445
R2146 Iin.n94 Iin.n93 0.1445
R2147 Iin.n95 Iin.n94 0.1445
R2148 Iin.n95 Iin.n29 0.1445
R2149 Iin.n110 Iin.n29 0.1445
R2150 Iin.n111 Iin.n110 0.1445
R2151 Iin.n112 Iin.n111 0.1445
R2152 Iin.n112 Iin.n16 0.1445
R2153 Iin.n130 Iin.n16 0.1445
R2154 Iin.n131 Iin.n130 0.1445
R2155 Iin.n132 Iin.n131 0.1445
R2156 Iin.n132 Iin.n1 0.1445
R2157 Iin.n70 Iin.n69 0.1445
R2158 Iin.n71 Iin.n70 0.1445
R2159 Iin.n71 Iin.n48 0.1445
R2160 Iin.n85 Iin.n48 0.1445
R2161 Iin.n86 Iin.n85 0.1445
R2162 Iin.n87 Iin.n86 0.1445
R2163 Iin.n87 Iin.n36 0.1445
R2164 Iin.n101 Iin.n36 0.1445
R2165 Iin.n102 Iin.n101 0.1445
R2166 Iin.n104 Iin.n102 0.1445
R2167 Iin.n104 Iin.n103 0.1445
R2168 Iin.n103 Iin.n23 0.1445
R2169 Iin.n119 Iin.n23 0.1445
R2170 Iin.n120 Iin.n119 0.1445
R2171 Iin.n121 Iin.n120 0.1445
R2172 Iin.n121 Iin.n4 0.1445
R2173 Iin.n591 Iin.n4 0.1445
R2174 Iin.n336 Iin.n223 0.107176
R2175 Iin.n335 Vss 0.0905
R2176 Vss Iin.n596 0.0905
R2177 Iin.n381 Iin.n380 0.0725
R2178 Iin.n380 Iin.n338 0.0725
R2179 Iin.n464 Iin.n463 0.0725
R2180 Iin.n463 Iin.n339 0.0725
R2181 Iin.n441 Iin.n440 0.0725
R2182 Iin.n440 Iin.n419 0.0725
R2183 Iin.n404 Iin.n403 0.0718661
R2184 Iin.n403 Iin.n402 0.0718661
R2185 Iin.n406 Iin.n223 0.0671
R2186 Iin.n398 Iin.n223 0.0599
R2187 Iin.n335 Vss 0.023
R2188 Iin.n596 Vss 0.023
R2189 Iin.n442 Iin.n418 0.0102035
R2190 Iin.n439 Iin.n418 0.0102035
R2191 Iin.n439 Iin.n438 0.0102035
R2192 Iin.n438 Iin.n420 0.0102035
R2193 Iin.n383 Iin.n382 0.0102035
R2194 Iin.n383 Iin.n358 0.0102035
R2195 Iin.n386 Iin.n358 0.0102035
R2196 Iin.n387 Iin.n386 0.0102035
R2197 Iin.n465 Iin.n337 0.0102035
R2198 Iin.n462 Iin.n337 0.0102035
R2199 Iin.n462 Iin.n461 0.0102035
R2200 Iin.n461 Iin.n340 0.0102035
R2201 Iin.n578 Iin.n140 0.005
R2202 Iin.n578 Iin.n577 0.005
R2203 Iin.n577 Iin.n141 0.005
R2204 Iin.n154 Iin.n141 0.005
R2205 Iin.n567 Iin.n154 0.005
R2206 Iin.n567 Iin.n566 0.005
R2207 Iin.n566 Iin.n155 0.005
R2208 Iin.n168 Iin.n155 0.005
R2209 Iin.n556 Iin.n168 0.005
R2210 Iin.n556 Iin.n555 0.005
R2211 Iin.n555 Iin.n169 0.005
R2212 Iin.n183 Iin.n169 0.005
R2213 Iin.n544 Iin.n183 0.005
R2214 Iin.n544 Iin.n543 0.005
R2215 Iin.n543 Iin.n184 0.005
R2216 Iin.n197 Iin.n184 0.005
R2217 Iin.n533 Iin.n197 0.005
R2218 Iin.n533 Iin.n532 0.005
R2219 Iin.n532 Iin.n198 0.005
R2220 Iin.n211 Iin.n198 0.005
R2221 Iin.n522 Iin.n211 0.005
R2222 Iin.n583 Iin.n7 0.00397994
R2223 Iin.n520 Iin.n213 0.00397994
R2224 Iin.n516 Iin.n213 0.00397994
R2225 Iin.n583 Iin.n136 0.00324045
R2226 Iin.n580 Iin.n579 0.00324045
R2227 Iin.n576 Iin.n139 0.00324045
R2228 Iin.n575 Iin.n143 0.00324045
R2229 Iin.n572 Iin.n150 0.00324045
R2230 Iin.n569 Iin.n568 0.00324045
R2231 Iin.n565 Iin.n153 0.00324045
R2232 Iin.n564 Iin.n157 0.00324045
R2233 Iin.n561 Iin.n164 0.00324045
R2234 Iin.n558 Iin.n557 0.00324045
R2235 Iin.n554 Iin.n167 0.00324045
R2236 Iin.n553 Iin.n171 0.00324045
R2237 Iin.n550 Iin.n178 0.00324045
R2238 Iin.n546 Iin.n545 0.00324045
R2239 Iin.n542 Iin.n182 0.00324045
R2240 Iin.n541 Iin.n186 0.00324045
R2241 Iin.n538 Iin.n193 0.00324045
R2242 Iin.n535 Iin.n534 0.00324045
R2243 Iin.n531 Iin.n196 0.00324045
R2244 Iin.n530 Iin.n200 0.00324045
R2245 Iin.n527 Iin.n207 0.00324045
R2246 Iin.n524 Iin.n523 0.00324045
R2247 Iin.n521 Iin.n210 0.00324045
R2248 Iin.n593 Iin.n2 0.00158748
R2249 Iin.n580 Iin.n136 0.00123949
R2250 Iin.n579 Iin.n139 0.00123949
R2251 Iin.n576 Iin.n575 0.00123949
R2252 Iin.n572 Iin.n143 0.00123949
R2253 Iin.n569 Iin.n150 0.00123949
R2254 Iin.n568 Iin.n153 0.00123949
R2255 Iin.n565 Iin.n564 0.00123949
R2256 Iin.n561 Iin.n157 0.00123949
R2257 Iin.n558 Iin.n164 0.00123949
R2258 Iin.n557 Iin.n167 0.00123949
R2259 Iin.n554 Iin.n553 0.00123949
R2260 Iin.n550 Iin.n171 0.00123949
R2261 Iin.n546 Iin.n178 0.00123949
R2262 Iin.n545 Iin.n182 0.00123949
R2263 Iin.n542 Iin.n541 0.00123949
R2264 Iin.n538 Iin.n186 0.00123949
R2265 Iin.n535 Iin.n193 0.00123949
R2266 Iin.n534 Iin.n196 0.00123949
R2267 Iin.n531 Iin.n530 0.00123949
R2268 Iin.n527 Iin.n200 0.00123949
R2269 Iin.n524 Iin.n207 0.00123949
R2270 Iin.n523 Iin.n210 0.00123949
R2271 Iin.n521 Iin.n520 0.00123949
R2272 Iin.n7 Iin.n2 0.00102199
R2273 Iin.n516 Iin.n221 0.000630498
R2274 spike_neg.n527 spike_neg.n66 18200
R2275 spike_neg.n526 spike_neg.n47 18200
R2276 spike_neg.n528 spike_neg.n527 14238.8
R2277 spike_neg.n527 spike_neg.n526 4468.75
R2278 spike_neg.n526 spike_neg.n525 4062.5
R2279 spike_neg.n529 spike_neg.n528 229.434
R2280 spike_neg.n508 spike_neg.n35 144.525
R2281 spike_neg.n445 spike_neg.n444 144.525
R2282 spike_neg.n455 spike_neg.n454 144.525
R2283 spike_neg.n469 spike_neg.n467 144.525
R2284 spike_neg.n592 spike_neg.n5 140.912
R2285 spike_neg.n591 spike_neg.n8 140.912
R2286 spike_neg.n549 spike_neg.n47 139.106
R2287 spike_neg.n457 spike_neg.n66 131.88
R2288 spike_neg.n561 spike_neg.n560 130.072
R2289 spike_neg.n502 spike_neg.n38 130.072
R2290 spike_neg.n471 spike_neg.n470 128.267
R2291 spike_neg.n483 spike_neg.n471 122.847
R2292 spike_neg.n482 spike_neg.n64 122.847
R2293 spike_neg.n502 spike_neg.n501 121.04
R2294 spike_neg.n548 spike_neg.n5 110.201
R2295 spike_neg.n458 spike_neg.n455 102.975
R2296 spike_neg.n235 spike_neg.n225 94.2375
R2297 spike_neg.n235 spike_neg.n219 94.2375
R2298 spike_neg.n243 spike_neg.n219 94.2375
R2299 spike_neg.n243 spike_neg.n213 94.2375
R2300 spike_neg.n251 spike_neg.n213 94.2375
R2301 spike_neg.n251 spike_neg.n207 94.2375
R2302 spike_neg.n259 spike_neg.n207 94.2375
R2303 spike_neg.n259 spike_neg.n201 94.2375
R2304 spike_neg.n267 spike_neg.n201 94.2375
R2305 spike_neg.n267 spike_neg.n195 94.2375
R2306 spike_neg.n275 spike_neg.n195 94.2375
R2307 spike_neg.n275 spike_neg.n189 94.2375
R2308 spike_neg.n283 spike_neg.n189 94.2375
R2309 spike_neg.n283 spike_neg.n183 94.2375
R2310 spike_neg.n292 spike_neg.n183 94.2375
R2311 spike_neg.n292 spike_neg.n176 94.2375
R2312 spike_neg.n302 spike_neg.n176 94.2375
R2313 spike_neg.n302 spike_neg.n301 94.2375
R2314 spike_neg.n301 spike_neg.n172 94.2375
R2315 spike_neg.n312 spike_neg.n172 94.2375
R2316 spike_neg.n312 spike_neg.n162 94.2375
R2317 spike_neg.n327 spike_neg.n162 94.2375
R2318 spike_neg.n328 spike_neg.n327 94.2375
R2319 spike_neg.n328 spike_neg.n154 94.2375
R2320 spike_neg.n338 spike_neg.n154 94.2375
R2321 spike_neg.n338 spike_neg.n143 94.2375
R2322 spike_neg.n353 spike_neg.n143 94.2375
R2323 spike_neg.n354 spike_neg.n353 94.2375
R2324 spike_neg.n354 spike_neg.n135 94.2375
R2325 spike_neg.n364 spike_neg.n135 94.2375
R2326 spike_neg.n364 spike_neg.n122 94.2375
R2327 spike_neg.n379 spike_neg.n122 94.2375
R2328 spike_neg.n380 spike_neg.n379 94.2375
R2329 spike_neg.n380 spike_neg.n113 94.2375
R2330 spike_neg.n392 spike_neg.n113 94.2375
R2331 spike_neg.n392 spike_neg.n114 94.2375
R2332 spike_neg.n114 spike_neg.n102 94.2375
R2333 spike_neg.n408 spike_neg.n102 94.2375
R2334 spike_neg.n408 spike_neg.n87 94.2375
R2335 spike_neg.n420 spike_neg.n87 94.2375
R2336 spike_neg.n421 spike_neg.n420 94.2375
R2337 spike_neg.n421 spike_neg.n79 94.2375
R2338 spike_neg.n429 spike_neg.n79 94.2375
R2339 spike_neg.n430 spike_neg.n429 94.2375
R2340 spike_neg.n430 spike_neg.n67 94.2375
R2341 spike_neg.n508 spike_neg.n69 92.135
R2342 spike_neg.n63 spike_neg.n22 84.0977
R2343 spike_neg.n530 spike_neg.n63 84.0977
R2344 spike_neg.n229 spike_neg.n224 84.0977
R2345 spike_neg.n525 spike_neg.n67 74.2122
R2346 spike_neg.n472 spike_neg.n65 69.0283
R2347 spike_neg.n466 spike_neg.n65 69.0283
R2348 spike_neg.n484 spike_neg.n465 69.0283
R2349 spike_neg.n481 spike_neg.n465 69.0283
R2350 spike_neg.n500 spike_neg.n446 69.0283
R2351 spike_neg.n500 spike_neg.n34 69.0283
R2352 spike_neg.n562 spike_neg.n33 69.0283
R2353 spike_neg.n36 spike_neg.n33 69.0283
R2354 spike_neg.n459 spike_neg.n3 69.0283
R2355 spike_neg.n460 spike_neg.n459 69.0283
R2356 spike_neg.n6 spike_neg.n4 69.0283
R2357 spike_neg.n593 spike_neg.n4 69.0283
R2358 spike_neg.n229 spike_neg.n228 52.7258
R2359 spike_neg.n524 spike_neg.n69 52.3907
R2360 spike_neg.n458 spike_neg.n457 41.5514
R2361 spike_neg.n549 spike_neg.n548 34.3251
R2362 spike_neg.n525 spike_neg.n524 30.712
R2363 spike_neg.n501 spike_neg.n445 23.4858
R2364 spike_neg.n483 spike_neg.n482 21.6792
R2365 spike_neg.n529 spike_neg.n64 21.6792
R2366 spike_neg.n596 spike_neg.n595 16.6691
R2367 spike_neg.n470 spike_neg.n469 16.2595
R2368 spike_neg.n484 spike_neg.n466 15.5561
R2369 spike_neg.n481 spike_neg.n472 15.5561
R2370 spike_neg.n562 spike_neg.n34 15.5561
R2371 spike_neg.n446 spike_neg.n36 15.5561
R2372 spike_neg.n234 spike_neg.n226 15.5561
R2373 spike_neg.n234 spike_neg.n218 15.5561
R2374 spike_neg.n244 spike_neg.n218 15.5561
R2375 spike_neg.n244 spike_neg.n214 15.5561
R2376 spike_neg.n250 spike_neg.n214 15.5561
R2377 spike_neg.n250 spike_neg.n206 15.5561
R2378 spike_neg.n260 spike_neg.n206 15.5561
R2379 spike_neg.n260 spike_neg.n202 15.5561
R2380 spike_neg.n266 spike_neg.n202 15.5561
R2381 spike_neg.n266 spike_neg.n194 15.5561
R2382 spike_neg.n276 spike_neg.n194 15.5561
R2383 spike_neg.n276 spike_neg.n190 15.5561
R2384 spike_neg.n282 spike_neg.n190 15.5561
R2385 spike_neg.n282 spike_neg.n181 15.5561
R2386 spike_neg.n293 spike_neg.n181 15.5561
R2387 spike_neg.n293 spike_neg.n182 15.5561
R2388 spike_neg.n182 spike_neg.n177 15.5561
R2389 spike_neg.n300 spike_neg.n177 15.5561
R2390 spike_neg.n300 spike_neg.n171 15.5561
R2391 spike_neg.n313 spike_neg.n171 15.5561
R2392 spike_neg.n314 spike_neg.n313 15.5561
R2393 spike_neg.n314 spike_neg.n161 15.5561
R2394 spike_neg.n329 spike_neg.n161 15.5561
R2395 spike_neg.n329 spike_neg.n153 15.5561
R2396 spike_neg.n339 spike_neg.n153 15.5561
R2397 spike_neg.n340 spike_neg.n339 15.5561
R2398 spike_neg.n340 spike_neg.n142 15.5561
R2399 spike_neg.n355 spike_neg.n142 15.5561
R2400 spike_neg.n355 spike_neg.n134 15.5561
R2401 spike_neg.n365 spike_neg.n134 15.5561
R2402 spike_neg.n366 spike_neg.n365 15.5561
R2403 spike_neg.n366 spike_neg.n121 15.5561
R2404 spike_neg.n381 spike_neg.n121 15.5561
R2405 spike_neg.n381 spike_neg.n112 15.5561
R2406 spike_neg.n393 spike_neg.n112 15.5561
R2407 spike_neg.n393 spike_neg.n103 15.5561
R2408 spike_neg.n406 spike_neg.n103 15.5561
R2409 spike_neg.n407 spike_neg.n406 15.5561
R2410 spike_neg.n407 spike_neg.n96 15.5561
R2411 spike_neg.n96 spike_neg.n86 15.5561
R2412 spike_neg.n422 spike_neg.n86 15.5561
R2413 spike_neg.n423 spike_neg.n422 15.5561
R2414 spike_neg.n423 spike_neg.n78 15.5561
R2415 spike_neg.n431 spike_neg.n78 15.5561
R2416 spike_neg.n512 spike_neg.n431 15.5561
R2417 spike_neg.n512 spike_neg.n68 15.5561
R2418 spike_neg.n509 spike_neg.n68 15.5561
R2419 spike_neg.n509 spike_neg.n507 15.5561
R2420 spike_neg.n507 spike_neg.n37 15.5561
R2421 spike_neg.n503 spike_neg.n37 15.5561
R2422 spike_neg.n503 spike_neg.n443 15.5561
R2423 spike_neg.n443 spike_neg.n48 15.5561
R2424 spike_neg.n547 spike_neg.n48 15.5561
R2425 spike_neg.n547 spike_neg.n49 15.5561
R2426 spike_neg.n49 spike_neg.n7 15.5561
R2427 spike_neg.n53 spike_neg.n7 15.5561
R2428 spike_neg.n54 spike_neg.n53 15.5561
R2429 spike_neg.n456 spike_neg.n54 15.5561
R2430 spike_neg.n456 spike_neg.n57 15.5561
R2431 spike_neg.n58 spike_neg.n57 15.5561
R2432 spike_neg.n59 spike_neg.n58 15.5561
R2433 spike_neg.n62 spike_neg.n59 15.5561
R2434 spike_neg.n530 spike_neg.n62 15.5561
R2435 spike_neg.n236 spike_neg.n224 15.5561
R2436 spike_neg.n236 spike_neg.n220 15.5561
R2437 spike_neg.n242 spike_neg.n220 15.5561
R2438 spike_neg.n242 spike_neg.n212 15.5561
R2439 spike_neg.n252 spike_neg.n212 15.5561
R2440 spike_neg.n252 spike_neg.n208 15.5561
R2441 spike_neg.n258 spike_neg.n208 15.5561
R2442 spike_neg.n258 spike_neg.n200 15.5561
R2443 spike_neg.n268 spike_neg.n200 15.5561
R2444 spike_neg.n268 spike_neg.n196 15.5561
R2445 spike_neg.n274 spike_neg.n196 15.5561
R2446 spike_neg.n274 spike_neg.n188 15.5561
R2447 spike_neg.n284 spike_neg.n188 15.5561
R2448 spike_neg.n284 spike_neg.n184 15.5561
R2449 spike_neg.n291 spike_neg.n184 15.5561
R2450 spike_neg.n291 spike_neg.n175 15.5561
R2451 spike_neg.n303 spike_neg.n175 15.5561
R2452 spike_neg.n303 spike_neg.n173 15.5561
R2453 spike_neg.n310 spike_neg.n173 15.5561
R2454 spike_neg.n311 spike_neg.n310 15.5561
R2455 spike_neg.n311 spike_neg.n163 15.5561
R2456 spike_neg.n326 spike_neg.n163 15.5561
R2457 spike_neg.n326 spike_neg.n155 15.5561
R2458 spike_neg.n336 spike_neg.n155 15.5561
R2459 spike_neg.n337 spike_neg.n336 15.5561
R2460 spike_neg.n337 spike_neg.n144 15.5561
R2461 spike_neg.n352 spike_neg.n144 15.5561
R2462 spike_neg.n352 spike_neg.n136 15.5561
R2463 spike_neg.n362 spike_neg.n136 15.5561
R2464 spike_neg.n363 spike_neg.n362 15.5561
R2465 spike_neg.n363 spike_neg.n123 15.5561
R2466 spike_neg.n378 spike_neg.n123 15.5561
R2467 spike_neg.n378 spike_neg.n115 15.5561
R2468 spike_neg.n388 spike_neg.n115 15.5561
R2469 spike_neg.n391 spike_neg.n388 15.5561
R2470 spike_neg.n391 spike_neg.n390 15.5561
R2471 spike_neg.n390 spike_neg.n101 15.5561
R2472 spike_neg.n409 spike_neg.n101 15.5561
R2473 spike_neg.n409 spike_neg.n88 15.5561
R2474 spike_neg.n419 spike_neg.n88 15.5561
R2475 spike_neg.n419 spike_neg.n80 15.5561
R2476 spike_neg.n427 spike_neg.n80 15.5561
R2477 spike_neg.n428 spike_neg.n427 15.5561
R2478 spike_neg.n428 spike_neg.n73 15.5561
R2479 spike_neg.n73 spike_neg.n70 15.5561
R2480 spike_neg.n523 spike_neg.n70 15.5561
R2481 spike_neg.n523 spike_neg.n71 15.5561
R2482 spike_neg.n71 spike_neg.n39 15.5561
R2483 spike_neg.n559 spike_neg.n39 15.5561
R2484 spike_neg.n559 spike_neg.n40 15.5561
R2485 spike_neg.n45 spike_neg.n40 15.5561
R2486 spike_neg.n46 spike_neg.n45 15.5561
R2487 spike_neg.n550 spike_neg.n46 15.5561
R2488 spike_neg.n550 spike_neg.n9 15.5561
R2489 spike_neg.n590 spike_neg.n9 15.5561
R2490 spike_neg.n590 spike_neg.n10 15.5561
R2491 spike_neg.n15 spike_neg.n10 15.5561
R2492 spike_neg.n16 spike_neg.n15 15.5561
R2493 spike_neg.n17 spike_neg.n16 15.5561
R2494 spike_neg.n468 spike_neg.n17 15.5561
R2495 spike_neg.n468 spike_neg.n20 15.5561
R2496 spike_neg.n21 spike_neg.n20 15.5561
R2497 spike_neg.n22 spike_neg.n21 15.5561
R2498 spike_neg.n460 spike_neg.n6 15.5561
R2499 spike_neg.n561 spike_neg.n35 14.453
R2500 spike_neg.n560 spike_neg.n38 14.453
R2501 spike_neg.n467 spike_neg.n66 12.6464
R2502 spike_neg.n515 spike_neg.n76 12.5005
R2503 spike_neg.n83 spike_neg.n74 12.5005
R2504 spike_neg.n425 spike_neg.n84 12.5005
R2505 spike_neg.n93 spike_neg.n92 12.5005
R2506 spike_neg.n417 spike_neg.n94 12.5005
R2507 spike_neg.n414 spike_neg.n413 12.5005
R2508 spike_neg.n412 spike_neg.n411 12.5005
R2509 spike_neg.n404 spike_neg.n98 12.5005
R2510 spike_neg.n109 spike_neg.n105 12.5005
R2511 spike_neg.n395 spike_neg.n110 12.5005
R2512 spike_neg.n386 spike_neg.n385 12.5005
R2513 spike_neg.n384 spike_neg.n383 12.5005
R2514 spike_neg.n376 spike_neg.n118 12.5005
R2515 spike_neg.n131 spike_neg.n125 12.5005
R2516 spike_neg.n369 spike_neg.n132 12.5005
R2517 spike_neg.n360 spike_neg.n359 12.5005
R2518 spike_neg.n358 spike_neg.n357 12.5005
R2519 spike_neg.n350 spike_neg.n139 12.5005
R2520 spike_neg.n150 spike_neg.n146 12.5005
R2521 spike_neg.n343 spike_neg.n151 12.5005
R2522 spike_neg.n334 spike_neg.n333 12.5005
R2523 spike_neg.n332 spike_neg.n331 12.5005
R2524 spike_neg.n324 spike_neg.n158 12.5005
R2525 spike_neg.n168 spike_neg.n165 12.5005
R2526 spike_neg.n317 spike_neg.n169 12.5005
R2527 spike_neg.n308 spike_neg.n307 12.5005
R2528 spike_neg.n306 spike_neg.n28 12.5005
R2529 spike_neg.n306 spike_neg.n27 11.7031
R2530 spike_neg.n432 spike_neg.n76 11.545
R2531 spike_neg.n573 spike_neg.n572 7.89186
R2532 spike_neg.n572 spike_neg.n25 7.75378
R2533 spike_neg.n574 spike_neg.n573 7.73533
R2534 spike_neg.n475 spike_neg.n61 6.395
R2535 spike_neg.n307 spike_neg.n306 5.61588
R2536 spike_neg.n307 spike_neg.n169 5.61588
R2537 spike_neg.n169 spike_neg.n168 5.61588
R2538 spike_neg.n168 spike_neg.n158 5.61588
R2539 spike_neg.n332 spike_neg.n158 5.61588
R2540 spike_neg.n333 spike_neg.n332 5.61588
R2541 spike_neg.n333 spike_neg.n151 5.61588
R2542 spike_neg.n151 spike_neg.n150 5.61588
R2543 spike_neg.n150 spike_neg.n139 5.61588
R2544 spike_neg.n358 spike_neg.n139 5.61588
R2545 spike_neg.n359 spike_neg.n358 5.61588
R2546 spike_neg.n359 spike_neg.n132 5.61588
R2547 spike_neg.n132 spike_neg.n131 5.61588
R2548 spike_neg.n384 spike_neg.n118 5.61588
R2549 spike_neg.n385 spike_neg.n384 5.61588
R2550 spike_neg.n385 spike_neg.n110 5.61588
R2551 spike_neg.n110 spike_neg.n109 5.61588
R2552 spike_neg.n109 spike_neg.n98 5.61588
R2553 spike_neg.n412 spike_neg.n98 5.61588
R2554 spike_neg.n413 spike_neg.n412 5.61588
R2555 spike_neg.n413 spike_neg.n94 5.61588
R2556 spike_neg.n94 spike_neg.n93 5.61588
R2557 spike_neg.n93 spike_neg.n84 5.61588
R2558 spike_neg.n84 spike_neg.n83 5.61588
R2559 spike_neg.n83 spike_neg.n76 5.61588
R2560 spike_neg.n567 Vss 5.4833
R2561 spike_neg.n444 spike_neg.n47 5.42018
R2562 spike_neg.n230 spike_neg.n222 5.35452
R2563 spike_neg.n231 spike_neg.n230 5.35452
R2564 spike_neg.n473 spike_neg.n462 5.20101
R2565 spike_neg.n447 spike_neg.n30 5.20101
R2566 spike_neg.n449 spike_neg.n446 5.2005
R2567 spike_neg.n446 spike_neg.n38 5.2005
R2568 spike_neg.n448 spike_neg.n36 5.2005
R2569 spike_neg.n561 spike_neg.n36 5.2005
R2570 spike_neg.n34 spike_neg.n32 5.2005
R2571 spike_neg.n38 spike_neg.n34 5.2005
R2572 spike_neg.n563 spike_neg.n562 5.2005
R2573 spike_neg.n562 spike_neg.n561 5.2005
R2574 spike_neg.n479 spike_neg.n472 5.2005
R2575 spike_neg.n472 spike_neg.n64 5.2005
R2576 spike_neg.n481 spike_neg.n480 5.2005
R2577 spike_neg.n483 spike_neg.n481 5.2005
R2578 spike_neg.n466 spike_neg.n464 5.2005
R2579 spike_neg.n466 spike_neg.n64 5.2005
R2580 spike_neg.n485 spike_neg.n484 5.2005
R2581 spike_neg.n484 spike_neg.n483 5.2005
R2582 spike_neg.n531 spike_neg.n530 5.2005
R2583 spike_neg.n530 spike_neg.n529 5.2005
R2584 spike_neg.n62 spike_neg.n60 5.2005
R2585 spike_neg.n482 spike_neg.n62 5.2005
R2586 spike_neg.n535 spike_neg.n59 5.2005
R2587 spike_neg.n471 spike_neg.n59 5.2005
R2588 spike_neg.n536 spike_neg.n58 5.2005
R2589 spike_neg.n469 spike_neg.n58 5.2005
R2590 spike_neg.n537 spike_neg.n57 5.2005
R2591 spike_neg.n467 spike_neg.n57 5.2005
R2592 spike_neg.n456 spike_neg.n55 5.2005
R2593 spike_neg.n457 spike_neg.n456 5.2005
R2594 spike_neg.n541 spike_neg.n54 5.2005
R2595 spike_neg.n455 spike_neg.n54 5.2005
R2596 spike_neg.n542 spike_neg.n53 5.2005
R2597 spike_neg.n454 spike_neg.n53 5.2005
R2598 spike_neg.n544 spike_neg.n7 5.2005
R2599 spike_neg.n591 spike_neg.n7 5.2005
R2600 spike_neg.n545 spike_neg.n49 5.2005
R2601 spike_neg.n49 spike_neg.n5 5.2005
R2602 spike_neg.n547 spike_neg.n546 5.2005
R2603 spike_neg.n549 spike_neg.n547 5.2005
R2604 spike_neg.n50 spike_neg.n48 5.2005
R2605 spike_neg.n444 spike_neg.n48 5.2005
R2606 spike_neg.n443 spike_neg.n442 5.2005
R2607 spike_neg.n445 spike_neg.n443 5.2005
R2608 spike_neg.n504 spike_neg.n503 5.2005
R2609 spike_neg.n503 spike_neg.n502 5.2005
R2610 spike_neg.n505 spike_neg.n37 5.2005
R2611 spike_neg.n560 spike_neg.n37 5.2005
R2612 spike_neg.n507 spike_neg.n506 5.2005
R2613 spike_neg.n507 spike_neg.n35 5.2005
R2614 spike_neg.n510 spike_neg.n509 5.2005
R2615 spike_neg.n509 spike_neg.n508 5.2005
R2616 spike_neg.n511 spike_neg.n68 5.2005
R2617 spike_neg.n524 spike_neg.n68 5.2005
R2618 spike_neg.n513 spike_neg.n512 5.2005
R2619 spike_neg.n512 spike_neg.n67 5.2005
R2620 spike_neg.n514 spike_neg.n431 5.2005
R2621 spike_neg.n431 spike_neg.n430 5.2005
R2622 spike_neg.n78 spike_neg.n77 5.2005
R2623 spike_neg.n429 spike_neg.n78 5.2005
R2624 spike_neg.n424 spike_neg.n423 5.2005
R2625 spike_neg.n423 spike_neg.n79 5.2005
R2626 spike_neg.n422 spike_neg.n85 5.2005
R2627 spike_neg.n422 spike_neg.n421 5.2005
R2628 spike_neg.n416 spike_neg.n86 5.2005
R2629 spike_neg.n420 spike_neg.n86 5.2005
R2630 spike_neg.n415 spike_neg.n96 5.2005
R2631 spike_neg.n96 spike_neg.n87 5.2005
R2632 spike_neg.n407 spike_neg.n95 5.2005
R2633 spike_neg.n408 spike_neg.n407 5.2005
R2634 spike_neg.n406 spike_neg.n405 5.2005
R2635 spike_neg.n406 spike_neg.n102 5.2005
R2636 spike_neg.n104 spike_neg.n103 5.2005
R2637 spike_neg.n114 spike_neg.n103 5.2005
R2638 spike_neg.n394 spike_neg.n393 5.2005
R2639 spike_neg.n393 spike_neg.n392 5.2005
R2640 spike_neg.n112 spike_neg.n111 5.2005
R2641 spike_neg.n113 spike_neg.n112 5.2005
R2642 spike_neg.n382 spike_neg.n381 5.2005
R2643 spike_neg.n381 spike_neg.n380 5.2005
R2644 spike_neg.n121 spike_neg.n120 5.2005
R2645 spike_neg.n379 spike_neg.n121 5.2005
R2646 spike_neg.n367 spike_neg.n366 5.2005
R2647 spike_neg.n366 spike_neg.n122 5.2005
R2648 spike_neg.n368 spike_neg.n365 5.2005
R2649 spike_neg.n365 spike_neg.n364 5.2005
R2650 spike_neg.n134 spike_neg.n133 5.2005
R2651 spike_neg.n135 spike_neg.n134 5.2005
R2652 spike_neg.n356 spike_neg.n355 5.2005
R2653 spike_neg.n355 spike_neg.n354 5.2005
R2654 spike_neg.n142 spike_neg.n141 5.2005
R2655 spike_neg.n353 spike_neg.n142 5.2005
R2656 spike_neg.n341 spike_neg.n340 5.2005
R2657 spike_neg.n340 spike_neg.n143 5.2005
R2658 spike_neg.n342 spike_neg.n339 5.2005
R2659 spike_neg.n339 spike_neg.n338 5.2005
R2660 spike_neg.n153 spike_neg.n152 5.2005
R2661 spike_neg.n154 spike_neg.n153 5.2005
R2662 spike_neg.n330 spike_neg.n329 5.2005
R2663 spike_neg.n329 spike_neg.n328 5.2005
R2664 spike_neg.n161 spike_neg.n160 5.2005
R2665 spike_neg.n327 spike_neg.n161 5.2005
R2666 spike_neg.n315 spike_neg.n314 5.2005
R2667 spike_neg.n314 spike_neg.n162 5.2005
R2668 spike_neg.n316 spike_neg.n313 5.2005
R2669 spike_neg.n313 spike_neg.n312 5.2005
R2670 spike_neg.n171 spike_neg.n170 5.2005
R2671 spike_neg.n172 spike_neg.n171 5.2005
R2672 spike_neg.n300 spike_neg.n299 5.2005
R2673 spike_neg.n301 spike_neg.n300 5.2005
R2674 spike_neg.n298 spike_neg.n177 5.2005
R2675 spike_neg.n302 spike_neg.n177 5.2005
R2676 spike_neg.n182 spike_neg.n178 5.2005
R2677 spike_neg.n182 spike_neg.n176 5.2005
R2678 spike_neg.n294 spike_neg.n293 5.2005
R2679 spike_neg.n293 spike_neg.n292 5.2005
R2680 spike_neg.n181 spike_neg.n180 5.2005
R2681 spike_neg.n183 spike_neg.n181 5.2005
R2682 spike_neg.n282 spike_neg.n281 5.2005
R2683 spike_neg.n283 spike_neg.n282 5.2005
R2684 spike_neg.n191 spike_neg.n190 5.2005
R2685 spike_neg.n190 spike_neg.n189 5.2005
R2686 spike_neg.n277 spike_neg.n276 5.2005
R2687 spike_neg.n276 spike_neg.n275 5.2005
R2688 spike_neg.n194 spike_neg.n193 5.2005
R2689 spike_neg.n195 spike_neg.n194 5.2005
R2690 spike_neg.n266 spike_neg.n265 5.2005
R2691 spike_neg.n267 spike_neg.n266 5.2005
R2692 spike_neg.n203 spike_neg.n202 5.2005
R2693 spike_neg.n202 spike_neg.n201 5.2005
R2694 spike_neg.n261 spike_neg.n260 5.2005
R2695 spike_neg.n260 spike_neg.n259 5.2005
R2696 spike_neg.n206 spike_neg.n205 5.2005
R2697 spike_neg.n207 spike_neg.n206 5.2005
R2698 spike_neg.n250 spike_neg.n249 5.2005
R2699 spike_neg.n251 spike_neg.n250 5.2005
R2700 spike_neg.n215 spike_neg.n214 5.2005
R2701 spike_neg.n214 spike_neg.n213 5.2005
R2702 spike_neg.n245 spike_neg.n244 5.2005
R2703 spike_neg.n244 spike_neg.n243 5.2005
R2704 spike_neg.n218 spike_neg.n217 5.2005
R2705 spike_neg.n219 spike_neg.n218 5.2005
R2706 spike_neg.n234 spike_neg.n233 5.2005
R2707 spike_neg.n235 spike_neg.n234 5.2005
R2708 spike_neg.n227 spike_neg.n226 5.2005
R2709 spike_neg.n577 spike_neg.n22 5.2005
R2710 spike_neg.n529 spike_neg.n22 5.2005
R2711 spike_neg.n578 spike_neg.n21 5.2005
R2712 spike_neg.n482 spike_neg.n21 5.2005
R2713 spike_neg.n579 spike_neg.n20 5.2005
R2714 spike_neg.n471 spike_neg.n20 5.2005
R2715 spike_neg.n468 spike_neg.n18 5.2005
R2716 spike_neg.n469 spike_neg.n468 5.2005
R2717 spike_neg.n583 spike_neg.n17 5.2005
R2718 spike_neg.n467 spike_neg.n17 5.2005
R2719 spike_neg.n584 spike_neg.n16 5.2005
R2720 spike_neg.n457 spike_neg.n16 5.2005
R2721 spike_neg.n585 spike_neg.n15 5.2005
R2722 spike_neg.n455 spike_neg.n15 5.2005
R2723 spike_neg.n12 spike_neg.n10 5.2005
R2724 spike_neg.n454 spike_neg.n10 5.2005
R2725 spike_neg.n590 spike_neg.n589 5.2005
R2726 spike_neg.n591 spike_neg.n590 5.2005
R2727 spike_neg.n11 spike_neg.n9 5.2005
R2728 spike_neg.n9 spike_neg.n5 5.2005
R2729 spike_neg.n552 spike_neg.n550 5.2005
R2730 spike_neg.n550 spike_neg.n549 5.2005
R2731 spike_neg.n553 spike_neg.n46 5.2005
R2732 spike_neg.n444 spike_neg.n46 5.2005
R2733 spike_neg.n554 spike_neg.n45 5.2005
R2734 spike_neg.n445 spike_neg.n45 5.2005
R2735 spike_neg.n42 spike_neg.n40 5.2005
R2736 spike_neg.n502 spike_neg.n40 5.2005
R2737 spike_neg.n559 spike_neg.n558 5.2005
R2738 spike_neg.n560 spike_neg.n559 5.2005
R2739 spike_neg.n41 spike_neg.n39 5.2005
R2740 spike_neg.n39 spike_neg.n35 5.2005
R2741 spike_neg.n518 spike_neg.n71 5.2005
R2742 spike_neg.n508 spike_neg.n71 5.2005
R2743 spike_neg.n523 spike_neg.n522 5.2005
R2744 spike_neg.n524 spike_neg.n523 5.2005
R2745 spike_neg.n517 spike_neg.n70 5.2005
R2746 spike_neg.n70 spike_neg.n67 5.2005
R2747 spike_neg.n516 spike_neg.n73 5.2005
R2748 spike_neg.n430 spike_neg.n73 5.2005
R2749 spike_neg.n428 spike_neg.n72 5.2005
R2750 spike_neg.n429 spike_neg.n428 5.2005
R2751 spike_neg.n427 spike_neg.n426 5.2005
R2752 spike_neg.n427 spike_neg.n79 5.2005
R2753 spike_neg.n81 spike_neg.n80 5.2005
R2754 spike_neg.n421 spike_neg.n80 5.2005
R2755 spike_neg.n419 spike_neg.n418 5.2005
R2756 spike_neg.n420 spike_neg.n419 5.2005
R2757 spike_neg.n89 spike_neg.n88 5.2005
R2758 spike_neg.n88 spike_neg.n87 5.2005
R2759 spike_neg.n410 spike_neg.n409 5.2005
R2760 spike_neg.n409 spike_neg.n408 5.2005
R2761 spike_neg.n101 spike_neg.n100 5.2005
R2762 spike_neg.n102 spike_neg.n101 5.2005
R2763 spike_neg.n390 spike_neg.n389 5.2005
R2764 spike_neg.n390 spike_neg.n114 5.2005
R2765 spike_neg.n391 spike_neg.n108 5.2005
R2766 spike_neg.n392 spike_neg.n391 5.2005
R2767 spike_neg.n388 spike_neg.n387 5.2005
R2768 spike_neg.n388 spike_neg.n113 5.2005
R2769 spike_neg.n116 spike_neg.n115 5.2005
R2770 spike_neg.n380 spike_neg.n115 5.2005
R2771 spike_neg.n378 spike_neg.n377 5.2005
R2772 spike_neg.n379 spike_neg.n378 5.2005
R2773 spike_neg.n124 spike_neg.n123 5.2005
R2774 spike_neg.n123 spike_neg.n122 5.2005
R2775 spike_neg.n363 spike_neg.n128 5.2005
R2776 spike_neg.n364 spike_neg.n363 5.2005
R2777 spike_neg.n362 spike_neg.n361 5.2005
R2778 spike_neg.n362 spike_neg.n135 5.2005
R2779 spike_neg.n137 spike_neg.n136 5.2005
R2780 spike_neg.n354 spike_neg.n136 5.2005
R2781 spike_neg.n352 spike_neg.n351 5.2005
R2782 spike_neg.n353 spike_neg.n352 5.2005
R2783 spike_neg.n145 spike_neg.n144 5.2005
R2784 spike_neg.n144 spike_neg.n143 5.2005
R2785 spike_neg.n337 spike_neg.n149 5.2005
R2786 spike_neg.n338 spike_neg.n337 5.2005
R2787 spike_neg.n336 spike_neg.n335 5.2005
R2788 spike_neg.n336 spike_neg.n154 5.2005
R2789 spike_neg.n156 spike_neg.n155 5.2005
R2790 spike_neg.n328 spike_neg.n155 5.2005
R2791 spike_neg.n326 spike_neg.n325 5.2005
R2792 spike_neg.n327 spike_neg.n326 5.2005
R2793 spike_neg.n164 spike_neg.n163 5.2005
R2794 spike_neg.n163 spike_neg.n162 5.2005
R2795 spike_neg.n311 spike_neg.n167 5.2005
R2796 spike_neg.n312 spike_neg.n311 5.2005
R2797 spike_neg.n310 spike_neg.n309 5.2005
R2798 spike_neg.n310 spike_neg.n172 5.2005
R2799 spike_neg.n305 spike_neg.n173 5.2005
R2800 spike_neg.n301 spike_neg.n173 5.2005
R2801 spike_neg.n304 spike_neg.n303 5.2005
R2802 spike_neg.n303 spike_neg.n302 5.2005
R2803 spike_neg.n175 spike_neg.n174 5.2005
R2804 spike_neg.n176 spike_neg.n175 5.2005
R2805 spike_neg.n291 spike_neg.n290 5.2005
R2806 spike_neg.n292 spike_neg.n291 5.2005
R2807 spike_neg.n185 spike_neg.n184 5.2005
R2808 spike_neg.n184 spike_neg.n183 5.2005
R2809 spike_neg.n285 spike_neg.n284 5.2005
R2810 spike_neg.n284 spike_neg.n283 5.2005
R2811 spike_neg.n188 spike_neg.n187 5.2005
R2812 spike_neg.n189 spike_neg.n188 5.2005
R2813 spike_neg.n274 spike_neg.n273 5.2005
R2814 spike_neg.n275 spike_neg.n274 5.2005
R2815 spike_neg.n197 spike_neg.n196 5.2005
R2816 spike_neg.n196 spike_neg.n195 5.2005
R2817 spike_neg.n269 spike_neg.n268 5.2005
R2818 spike_neg.n268 spike_neg.n267 5.2005
R2819 spike_neg.n200 spike_neg.n199 5.2005
R2820 spike_neg.n201 spike_neg.n200 5.2005
R2821 spike_neg.n258 spike_neg.n257 5.2005
R2822 spike_neg.n259 spike_neg.n258 5.2005
R2823 spike_neg.n209 spike_neg.n208 5.2005
R2824 spike_neg.n208 spike_neg.n207 5.2005
R2825 spike_neg.n253 spike_neg.n252 5.2005
R2826 spike_neg.n252 spike_neg.n251 5.2005
R2827 spike_neg.n212 spike_neg.n211 5.2005
R2828 spike_neg.n213 spike_neg.n212 5.2005
R2829 spike_neg.n242 spike_neg.n241 5.2005
R2830 spike_neg.n243 spike_neg.n242 5.2005
R2831 spike_neg.n221 spike_neg.n220 5.2005
R2832 spike_neg.n220 spike_neg.n219 5.2005
R2833 spike_neg.n237 spike_neg.n236 5.2005
R2834 spike_neg.n236 spike_neg.n235 5.2005
R2835 spike_neg.n224 spike_neg.n223 5.2005
R2836 spike_neg.n225 spike_neg.n224 5.2005
R2837 spike_neg.n492 spike_neg.n460 5.2005
R2838 spike_neg.n460 spike_neg.n8 5.2005
R2839 spike_neg.n493 spike_neg.n6 5.2005
R2840 spike_neg.n592 spike_neg.n6 5.2005
R2841 spike_neg.n8 spike_neg.n3 5.2005
R2842 spike_neg.n593 spike_neg.n592 5.2005
R2843 spike_neg.n478 spike_neg.n477 5.19319
R2844 spike_neg.n499 spike_neg.n450 5.19319
R2845 spike_neg.n61 spike_neg.n23 5.12952
R2846 spike_neg.n595 spike_neg.n1 5.12001
R2847 spike_neg.n595 spike_neg.n0 5.11219
R2848 spike_neg.n576 spike_neg.n575 5.04833
R2849 spike_neg.n477 spike_neg.n476 5.00286
R2850 spike_neg.n499 spike_neg.n498 5.00286
R2851 spike_neg.n495 spike_neg.n1 5.00286
R2852 spike_neg.n487 spike_neg.n462 5.00286
R2853 spike_neg.n565 spike_neg.n30 5.00286
R2854 spike_neg.n490 spike_neg.n0 5.00286
R2855 spike_neg.n575 spike_neg.n574 4.7183
R2856 spike_neg.n571 spike_neg.n570 4.5005
R2857 spike_neg.n474 spike_neg.n464 4.5005
R2858 spike_neg.n486 spike_neg.n485 4.5005
R2859 spike_neg.n479 spike_neg.n478 4.5005
R2860 spike_neg.n480 spike_neg.n473 4.5005
R2861 spike_neg.n451 spike_neg.n32 4.5005
R2862 spike_neg.n564 spike_neg.n563 4.5005
R2863 spike_neg.n450 spike_neg.n449 4.5005
R2864 spike_neg.n448 spike_neg.n447 4.5005
R2865 spike_neg.n513 spike_neg.n434 4.5005
R2866 spike_neg.n511 spike_neg.n435 4.5005
R2867 spike_neg.n510 spike_neg.n436 4.5005
R2868 spike_neg.n506 spike_neg.n437 4.5005
R2869 spike_neg.n505 spike_neg.n438 4.5005
R2870 spike_neg.n504 spike_neg.n439 4.5005
R2871 spike_neg.n442 spike_neg.n441 4.5005
R2872 spike_neg.n440 spike_neg.n50 4.5005
R2873 spike_neg.n546 spike_neg.n51 4.5005
R2874 spike_neg.n545 spike_neg.n52 4.5005
R2875 spike_neg.n238 spike_neg.n237 4.5005
R2876 spike_neg.n239 spike_neg.n221 4.5005
R2877 spike_neg.n241 spike_neg.n240 4.5005
R2878 spike_neg.n211 spike_neg.n210 4.5005
R2879 spike_neg.n254 spike_neg.n253 4.5005
R2880 spike_neg.n255 spike_neg.n209 4.5005
R2881 spike_neg.n257 spike_neg.n256 4.5005
R2882 spike_neg.n199 spike_neg.n198 4.5005
R2883 spike_neg.n270 spike_neg.n269 4.5005
R2884 spike_neg.n271 spike_neg.n197 4.5005
R2885 spike_neg.n273 spike_neg.n272 4.5005
R2886 spike_neg.n187 spike_neg.n186 4.5005
R2887 spike_neg.n286 spike_neg.n285 4.5005
R2888 spike_neg.n287 spike_neg.n185 4.5005
R2889 spike_neg.n290 spike_neg.n289 4.5005
R2890 spike_neg.n288 spike_neg.n174 4.5005
R2891 spike_neg.n304 spike_neg.n26 4.5005
R2892 spike_neg.n223 spike_neg.n222 4.5005
R2893 spike_neg.n233 spike_neg.n232 4.5005
R2894 spike_neg.n217 spike_neg.n216 4.5005
R2895 spike_neg.n246 spike_neg.n245 4.5005
R2896 spike_neg.n247 spike_neg.n215 4.5005
R2897 spike_neg.n249 spike_neg.n248 4.5005
R2898 spike_neg.n205 spike_neg.n204 4.5005
R2899 spike_neg.n262 spike_neg.n261 4.5005
R2900 spike_neg.n263 spike_neg.n203 4.5005
R2901 spike_neg.n265 spike_neg.n264 4.5005
R2902 spike_neg.n193 spike_neg.n192 4.5005
R2903 spike_neg.n278 spike_neg.n277 4.5005
R2904 spike_neg.n279 spike_neg.n191 4.5005
R2905 spike_neg.n281 spike_neg.n280 4.5005
R2906 spike_neg.n180 spike_neg.n179 4.5005
R2907 spike_neg.n295 spike_neg.n294 4.5005
R2908 spike_neg.n296 spike_neg.n178 4.5005
R2909 spike_neg.n298 spike_neg.n297 4.5005
R2910 spike_neg.n231 spike_neg.n227 4.5005
R2911 spike_neg.n305 spike_neg.n28 4.5005
R2912 spike_neg.n309 spike_neg.n308 4.5005
R2913 spike_neg.n317 spike_neg.n167 4.5005
R2914 spike_neg.n165 spike_neg.n164 4.5005
R2915 spike_neg.n325 spike_neg.n324 4.5005
R2916 spike_neg.n331 spike_neg.n156 4.5005
R2917 spike_neg.n335 spike_neg.n334 4.5005
R2918 spike_neg.n343 spike_neg.n149 4.5005
R2919 spike_neg.n146 spike_neg.n145 4.5005
R2920 spike_neg.n351 spike_neg.n350 4.5005
R2921 spike_neg.n357 spike_neg.n137 4.5005
R2922 spike_neg.n361 spike_neg.n360 4.5005
R2923 spike_neg.n369 spike_neg.n128 4.5005
R2924 spike_neg.n125 spike_neg.n124 4.5005
R2925 spike_neg.n377 spike_neg.n376 4.5005
R2926 spike_neg.n383 spike_neg.n116 4.5005
R2927 spike_neg.n387 spike_neg.n386 4.5005
R2928 spike_neg.n395 spike_neg.n108 4.5005
R2929 spike_neg.n389 spike_neg.n105 4.5005
R2930 spike_neg.n404 spike_neg.n100 4.5005
R2931 spike_neg.n411 spike_neg.n410 4.5005
R2932 spike_neg.n414 spike_neg.n89 4.5005
R2933 spike_neg.n418 spike_neg.n417 4.5005
R2934 spike_neg.n92 spike_neg.n81 4.5005
R2935 spike_neg.n426 spike_neg.n425 4.5005
R2936 spike_neg.n74 spike_neg.n72 4.5005
R2937 spike_neg.n516 spike_neg.n515 4.5005
R2938 spike_neg.n299 spike_neg.n28 4.5005
R2939 spike_neg.n308 spike_neg.n170 4.5005
R2940 spike_neg.n317 spike_neg.n316 4.5005
R2941 spike_neg.n315 spike_neg.n165 4.5005
R2942 spike_neg.n324 spike_neg.n160 4.5005
R2943 spike_neg.n331 spike_neg.n330 4.5005
R2944 spike_neg.n334 spike_neg.n152 4.5005
R2945 spike_neg.n343 spike_neg.n342 4.5005
R2946 spike_neg.n341 spike_neg.n146 4.5005
R2947 spike_neg.n350 spike_neg.n141 4.5005
R2948 spike_neg.n357 spike_neg.n356 4.5005
R2949 spike_neg.n360 spike_neg.n133 4.5005
R2950 spike_neg.n369 spike_neg.n368 4.5005
R2951 spike_neg.n367 spike_neg.n125 4.5005
R2952 spike_neg.n376 spike_neg.n120 4.5005
R2953 spike_neg.n383 spike_neg.n382 4.5005
R2954 spike_neg.n386 spike_neg.n111 4.5005
R2955 spike_neg.n395 spike_neg.n394 4.5005
R2956 spike_neg.n105 spike_neg.n104 4.5005
R2957 spike_neg.n405 spike_neg.n404 4.5005
R2958 spike_neg.n411 spike_neg.n95 4.5005
R2959 spike_neg.n415 spike_neg.n414 4.5005
R2960 spike_neg.n417 spike_neg.n416 4.5005
R2961 spike_neg.n92 spike_neg.n85 4.5005
R2962 spike_neg.n425 spike_neg.n424 4.5005
R2963 spike_neg.n77 spike_neg.n74 4.5005
R2964 spike_neg.n515 spike_neg.n514 4.5005
R2965 spike_neg.n519 spike_neg.n517 4.5005
R2966 spike_neg.n522 spike_neg.n521 4.5005
R2967 spike_neg.n520 spike_neg.n518 4.5005
R2968 spike_neg.n43 spike_neg.n41 4.5005
R2969 spike_neg.n558 spike_neg.n557 4.5005
R2970 spike_neg.n556 spike_neg.n42 4.5005
R2971 spike_neg.n555 spike_neg.n554 4.5005
R2972 spike_neg.n553 spike_neg.n44 4.5005
R2973 spike_neg.n552 spike_neg.n551 4.5005
R2974 spike_neg.n13 spike_neg.n11 4.5005
R2975 spike_neg.n589 spike_neg.n588 4.5005
R2976 spike_neg.n587 spike_neg.n12 4.5005
R2977 spike_neg.n586 spike_neg.n585 4.5005
R2978 spike_neg.n584 spike_neg.n14 4.5005
R2979 spike_neg.n583 spike_neg.n582 4.5005
R2980 spike_neg.n581 spike_neg.n18 4.5005
R2981 spike_neg.n580 spike_neg.n579 4.5005
R2982 spike_neg.n578 spike_neg.n19 4.5005
R2983 spike_neg.n577 spike_neg.n576 4.5005
R2984 spike_neg.n541 spike_neg.n540 4.5005
R2985 spike_neg.n539 spike_neg.n55 4.5005
R2986 spike_neg.n538 spike_neg.n537 4.5005
R2987 spike_neg.n536 spike_neg.n56 4.5005
R2988 spike_neg.n535 spike_neg.n534 4.5005
R2989 spike_neg.n533 spike_neg.n60 4.5005
R2990 spike_neg.n532 spike_neg.n531 4.5005
R2991 spike_neg.n498 spike_neg.n497 4.5005
R2992 spike_neg.n31 spike_neg.n29 4.5005
R2993 spike_neg.n566 spike_neg.n565 4.5005
R2994 spike_neg.n476 spike_neg.n475 4.5005
R2995 spike_neg.n463 spike_neg.n461 4.5005
R2996 spike_neg.n488 spike_neg.n487 4.5005
R2997 spike_neg.n490 spike_neg.n489 4.5005
R2998 spike_neg.n453 spike_neg.n452 4.5005
R2999 spike_neg.n496 spike_neg.n495 4.5005
R3000 spike_neg.n492 spike_neg.n491 4.5005
R3001 spike_neg.n494 spike_neg.n493 4.5005
R3002 spike_neg.n592 spike_neg.n591 3.61362
R3003 spike_neg.n454 spike_neg.n8 3.61362
R3004 spike_neg.n595 spike_neg.n594 3.28078
R3005 spike_neg.n228 spike_neg.n225 3.26114
R3006 spike_neg.n594 spike_neg.n593 3.14293
R3007 spike_neg.n594 spike_neg.n3 3.14293
R3008 spike_neg.n131 spike_neg.n130 2.80819
R3009 spike_neg.n130 spike_neg.n118 2.80819
R3010 spike_neg.n574 spike_neg.n24 2.6735
R3011 spike_neg.n543 spike_neg.n2 2.21557
R3012 spike_neg.n571 spike_neg.n569 2.1983
R3013 spike_neg.n228 spike_neg.n226 1.82789
R3014 spike_neg.n432 spike_neg.n2 1.23277
R3015 Vss spike_neg.n566 1.1597
R3016 spike_neg.n33 spike_neg.n30 0.743357
R3017 spike_neg.n69 spike_neg.n33 0.743357
R3018 spike_neg.n500 spike_neg.n499 0.743357
R3019 spike_neg.n501 spike_neg.n500 0.743357
R3020 spike_neg.n465 spike_neg.n462 0.743357
R3021 spike_neg.n470 spike_neg.n465 0.743357
R3022 spike_neg.n477 spike_neg.n65 0.743357
R3023 spike_neg.n528 spike_neg.n65 0.743357
R3024 spike_neg.n459 spike_neg.n0 0.743357
R3025 spike_neg.n459 spike_neg.n458 0.743357
R3026 spike_neg.n4 spike_neg.n1 0.743357
R3027 spike_neg.n548 spike_neg.n4 0.743357
R3028 spike_neg.n569 spike_neg.n568 0.573125
R3029 spike_neg.n568 spike_neg.n27 0.483125
R3030 spike_neg.n433 spike_neg.n75 0.483125
R3031 spike_neg.n230 spike_neg.n229 0.473227
R3032 spike_neg.n63 spike_neg.n23 0.473227
R3033 spike_neg.n528 spike_neg.n63 0.473227
R3034 spike_neg.n519 spike_neg.n24 0.44735
R3035 spike_neg.n75 spike_neg.n24 0.393125
R3036 spike_neg.n497 spike_neg.n496 0.3515
R3037 spike_neg.n489 spike_neg.n488 0.3515
R3038 spike_neg.n575 spike_neg.n23 0.29887
R3039 spike_neg.n398 spike_neg.n82 0.28625
R3040 spike_neg.n398 spike_neg.n91 0.28175
R3041 spike_neg.n399 spike_neg.n90 0.28175
R3042 spike_neg.n400 spike_neg.n97 0.28175
R3043 spike_neg.n401 spike_neg.n99 0.28175
R3044 spike_neg.n403 spike_neg.n402 0.28175
R3045 spike_neg.n397 spike_neg.n396 0.28175
R3046 spike_neg.n107 spike_neg.n106 0.28175
R3047 spike_neg.n372 spike_neg.n117 0.28175
R3048 spike_neg.n373 spike_neg.n119 0.28175
R3049 spike_neg.n375 spike_neg.n374 0.28175
R3050 spike_neg.n371 spike_neg.n370 0.28175
R3051 spike_neg.n127 spike_neg.n126 0.28175
R3052 spike_neg.n346 spike_neg.n138 0.28175
R3053 spike_neg.n347 spike_neg.n140 0.28175
R3054 spike_neg.n349 spike_neg.n348 0.28175
R3055 spike_neg.n345 spike_neg.n344 0.28175
R3056 spike_neg.n148 spike_neg.n147 0.28175
R3057 spike_neg.n320 spike_neg.n157 0.28175
R3058 spike_neg.n321 spike_neg.n159 0.28175
R3059 spike_neg.n323 spike_neg.n322 0.28175
R3060 spike_neg.n319 spike_neg.n318 0.28175
R3061 spike_neg.n166 spike_neg.n25 0.28175
R3062 spike_neg.n572 spike_neg.n571 0.2705
R3063 spike_neg.n434 spike_neg.n433 0.26735
R3064 spike_neg.n532 spike_neg.n61 0.2255
R3065 spike_neg.n433 spike_neg.n432 0.219838
R3066 spike_neg.n569 spike_neg.n26 0.20615
R3067 spike_neg.n297 spike_neg.n27 0.20615
R3068 spike_neg.n130 spike_neg.n129 0.1684
R3069 spike_neg.n493 spike_neg.n492 0.1445
R3070 spike_neg.n485 spike_neg.n464 0.1445
R3071 spike_neg.n478 spike_neg.n473 0.1445
R3072 spike_neg.n480 spike_neg.n479 0.1445
R3073 spike_neg.n563 spike_neg.n32 0.1445
R3074 spike_neg.n450 spike_neg.n447 0.1445
R3075 spike_neg.n449 spike_neg.n448 0.1445
R3076 spike_neg.n435 spike_neg.n434 0.1445
R3077 spike_neg.n436 spike_neg.n435 0.1445
R3078 spike_neg.n437 spike_neg.n436 0.1445
R3079 spike_neg.n438 spike_neg.n437 0.1445
R3080 spike_neg.n439 spike_neg.n438 0.1445
R3081 spike_neg.n441 spike_neg.n439 0.1445
R3082 spike_neg.n441 spike_neg.n440 0.1445
R3083 spike_neg.n440 spike_neg.n51 0.1445
R3084 spike_neg.n52 spike_neg.n51 0.1445
R3085 spike_neg.n233 spike_neg.n227 0.1445
R3086 spike_neg.n233 spike_neg.n217 0.1445
R3087 spike_neg.n245 spike_neg.n217 0.1445
R3088 spike_neg.n245 spike_neg.n215 0.1445
R3089 spike_neg.n249 spike_neg.n215 0.1445
R3090 spike_neg.n249 spike_neg.n205 0.1445
R3091 spike_neg.n261 spike_neg.n205 0.1445
R3092 spike_neg.n261 spike_neg.n203 0.1445
R3093 spike_neg.n265 spike_neg.n203 0.1445
R3094 spike_neg.n265 spike_neg.n193 0.1445
R3095 spike_neg.n277 spike_neg.n193 0.1445
R3096 spike_neg.n277 spike_neg.n191 0.1445
R3097 spike_neg.n281 spike_neg.n191 0.1445
R3098 spike_neg.n281 spike_neg.n180 0.1445
R3099 spike_neg.n294 spike_neg.n180 0.1445
R3100 spike_neg.n294 spike_neg.n178 0.1445
R3101 spike_neg.n298 spike_neg.n178 0.1445
R3102 spike_neg.n299 spike_neg.n298 0.1445
R3103 spike_neg.n299 spike_neg.n170 0.1445
R3104 spike_neg.n316 spike_neg.n170 0.1445
R3105 spike_neg.n316 spike_neg.n315 0.1445
R3106 spike_neg.n315 spike_neg.n160 0.1445
R3107 spike_neg.n330 spike_neg.n160 0.1445
R3108 spike_neg.n330 spike_neg.n152 0.1445
R3109 spike_neg.n342 spike_neg.n152 0.1445
R3110 spike_neg.n342 spike_neg.n341 0.1445
R3111 spike_neg.n341 spike_neg.n141 0.1445
R3112 spike_neg.n356 spike_neg.n141 0.1445
R3113 spike_neg.n356 spike_neg.n133 0.1445
R3114 spike_neg.n368 spike_neg.n133 0.1445
R3115 spike_neg.n368 spike_neg.n367 0.1445
R3116 spike_neg.n367 spike_neg.n120 0.1445
R3117 spike_neg.n382 spike_neg.n120 0.1445
R3118 spike_neg.n382 spike_neg.n111 0.1445
R3119 spike_neg.n394 spike_neg.n111 0.1445
R3120 spike_neg.n394 spike_neg.n104 0.1445
R3121 spike_neg.n405 spike_neg.n104 0.1445
R3122 spike_neg.n405 spike_neg.n95 0.1445
R3123 spike_neg.n415 spike_neg.n95 0.1445
R3124 spike_neg.n416 spike_neg.n415 0.1445
R3125 spike_neg.n416 spike_neg.n85 0.1445
R3126 spike_neg.n424 spike_neg.n85 0.1445
R3127 spike_neg.n424 spike_neg.n77 0.1445
R3128 spike_neg.n514 spike_neg.n77 0.1445
R3129 spike_neg.n514 spike_neg.n513 0.1445
R3130 spike_neg.n513 spike_neg.n511 0.1445
R3131 spike_neg.n511 spike_neg.n510 0.1445
R3132 spike_neg.n510 spike_neg.n506 0.1445
R3133 spike_neg.n506 spike_neg.n505 0.1445
R3134 spike_neg.n505 spike_neg.n504 0.1445
R3135 spike_neg.n504 spike_neg.n442 0.1445
R3136 spike_neg.n442 spike_neg.n50 0.1445
R3137 spike_neg.n546 spike_neg.n50 0.1445
R3138 spike_neg.n546 spike_neg.n545 0.1445
R3139 spike_neg.n545 spike_neg.n544 0.1445
R3140 spike_neg.n542 spike_neg.n541 0.1445
R3141 spike_neg.n541 spike_neg.n55 0.1445
R3142 spike_neg.n537 spike_neg.n55 0.1445
R3143 spike_neg.n537 spike_neg.n536 0.1445
R3144 spike_neg.n536 spike_neg.n535 0.1445
R3145 spike_neg.n535 spike_neg.n60 0.1445
R3146 spike_neg.n531 spike_neg.n60 0.1445
R3147 spike_neg.n237 spike_neg.n223 0.1445
R3148 spike_neg.n237 spike_neg.n221 0.1445
R3149 spike_neg.n241 spike_neg.n221 0.1445
R3150 spike_neg.n241 spike_neg.n211 0.1445
R3151 spike_neg.n253 spike_neg.n211 0.1445
R3152 spike_neg.n253 spike_neg.n209 0.1445
R3153 spike_neg.n257 spike_neg.n209 0.1445
R3154 spike_neg.n257 spike_neg.n199 0.1445
R3155 spike_neg.n269 spike_neg.n199 0.1445
R3156 spike_neg.n269 spike_neg.n197 0.1445
R3157 spike_neg.n273 spike_neg.n197 0.1445
R3158 spike_neg.n273 spike_neg.n187 0.1445
R3159 spike_neg.n285 spike_neg.n187 0.1445
R3160 spike_neg.n285 spike_neg.n185 0.1445
R3161 spike_neg.n290 spike_neg.n185 0.1445
R3162 spike_neg.n290 spike_neg.n174 0.1445
R3163 spike_neg.n304 spike_neg.n174 0.1445
R3164 spike_neg.n305 spike_neg.n304 0.1445
R3165 spike_neg.n309 spike_neg.n305 0.1445
R3166 spike_neg.n309 spike_neg.n167 0.1445
R3167 spike_neg.n167 spike_neg.n164 0.1445
R3168 spike_neg.n325 spike_neg.n164 0.1445
R3169 spike_neg.n325 spike_neg.n156 0.1445
R3170 spike_neg.n335 spike_neg.n156 0.1445
R3171 spike_neg.n335 spike_neg.n149 0.1445
R3172 spike_neg.n149 spike_neg.n145 0.1445
R3173 spike_neg.n351 spike_neg.n145 0.1445
R3174 spike_neg.n351 spike_neg.n137 0.1445
R3175 spike_neg.n361 spike_neg.n137 0.1445
R3176 spike_neg.n361 spike_neg.n128 0.1445
R3177 spike_neg.n128 spike_neg.n124 0.1445
R3178 spike_neg.n377 spike_neg.n124 0.1445
R3179 spike_neg.n377 spike_neg.n116 0.1445
R3180 spike_neg.n387 spike_neg.n116 0.1445
R3181 spike_neg.n387 spike_neg.n108 0.1445
R3182 spike_neg.n389 spike_neg.n108 0.1445
R3183 spike_neg.n389 spike_neg.n100 0.1445
R3184 spike_neg.n410 spike_neg.n100 0.1445
R3185 spike_neg.n410 spike_neg.n89 0.1445
R3186 spike_neg.n418 spike_neg.n89 0.1445
R3187 spike_neg.n418 spike_neg.n81 0.1445
R3188 spike_neg.n426 spike_neg.n81 0.1445
R3189 spike_neg.n426 spike_neg.n72 0.1445
R3190 spike_neg.n516 spike_neg.n72 0.1445
R3191 spike_neg.n517 spike_neg.n516 0.1445
R3192 spike_neg.n522 spike_neg.n517 0.1445
R3193 spike_neg.n522 spike_neg.n518 0.1445
R3194 spike_neg.n518 spike_neg.n41 0.1445
R3195 spike_neg.n558 spike_neg.n41 0.1445
R3196 spike_neg.n558 spike_neg.n42 0.1445
R3197 spike_neg.n554 spike_neg.n42 0.1445
R3198 spike_neg.n554 spike_neg.n553 0.1445
R3199 spike_neg.n553 spike_neg.n552 0.1445
R3200 spike_neg.n552 spike_neg.n11 0.1445
R3201 spike_neg.n589 spike_neg.n11 0.1445
R3202 spike_neg.n589 spike_neg.n12 0.1445
R3203 spike_neg.n585 spike_neg.n12 0.1445
R3204 spike_neg.n585 spike_neg.n584 0.1445
R3205 spike_neg.n584 spike_neg.n583 0.1445
R3206 spike_neg.n583 spike_neg.n18 0.1445
R3207 spike_neg.n579 spike_neg.n18 0.1445
R3208 spike_neg.n579 spike_neg.n578 0.1445
R3209 spike_neg.n578 spike_neg.n577 0.1445
R3210 spike_neg.n238 spike_neg.n222 0.1445
R3211 spike_neg.n239 spike_neg.n238 0.1445
R3212 spike_neg.n240 spike_neg.n239 0.1445
R3213 spike_neg.n240 spike_neg.n210 0.1445
R3214 spike_neg.n254 spike_neg.n210 0.1445
R3215 spike_neg.n255 spike_neg.n254 0.1445
R3216 spike_neg.n256 spike_neg.n255 0.1445
R3217 spike_neg.n256 spike_neg.n198 0.1445
R3218 spike_neg.n270 spike_neg.n198 0.1445
R3219 spike_neg.n271 spike_neg.n270 0.1445
R3220 spike_neg.n272 spike_neg.n271 0.1445
R3221 spike_neg.n272 spike_neg.n186 0.1445
R3222 spike_neg.n286 spike_neg.n186 0.1445
R3223 spike_neg.n287 spike_neg.n286 0.1445
R3224 spike_neg.n289 spike_neg.n287 0.1445
R3225 spike_neg.n289 spike_neg.n288 0.1445
R3226 spike_neg.n288 spike_neg.n26 0.1445
R3227 spike_neg.n232 spike_neg.n231 0.1445
R3228 spike_neg.n232 spike_neg.n216 0.1445
R3229 spike_neg.n246 spike_neg.n216 0.1445
R3230 spike_neg.n247 spike_neg.n246 0.1445
R3231 spike_neg.n248 spike_neg.n247 0.1445
R3232 spike_neg.n248 spike_neg.n204 0.1445
R3233 spike_neg.n262 spike_neg.n204 0.1445
R3234 spike_neg.n263 spike_neg.n262 0.1445
R3235 spike_neg.n264 spike_neg.n263 0.1445
R3236 spike_neg.n264 spike_neg.n192 0.1445
R3237 spike_neg.n278 spike_neg.n192 0.1445
R3238 spike_neg.n279 spike_neg.n278 0.1445
R3239 spike_neg.n280 spike_neg.n279 0.1445
R3240 spike_neg.n280 spike_neg.n179 0.1445
R3241 spike_neg.n295 spike_neg.n179 0.1445
R3242 spike_neg.n296 spike_neg.n295 0.1445
R3243 spike_neg.n297 spike_neg.n296 0.1445
R3244 spike_neg.n521 spike_neg.n519 0.1445
R3245 spike_neg.n521 spike_neg.n520 0.1445
R3246 spike_neg.n520 spike_neg.n43 0.1445
R3247 spike_neg.n557 spike_neg.n43 0.1445
R3248 spike_neg.n557 spike_neg.n556 0.1445
R3249 spike_neg.n556 spike_neg.n555 0.1445
R3250 spike_neg.n555 spike_neg.n44 0.1445
R3251 spike_neg.n551 spike_neg.n44 0.1445
R3252 spike_neg.n551 spike_neg.n13 0.1445
R3253 spike_neg.n588 spike_neg.n13 0.1445
R3254 spike_neg.n588 spike_neg.n587 0.1445
R3255 spike_neg.n587 spike_neg.n586 0.1445
R3256 spike_neg.n586 spike_neg.n14 0.1445
R3257 spike_neg.n582 spike_neg.n14 0.1445
R3258 spike_neg.n582 spike_neg.n581 0.1445
R3259 spike_neg.n581 spike_neg.n580 0.1445
R3260 spike_neg.n580 spike_neg.n19 0.1445
R3261 spike_neg.n576 spike_neg.n19 0.1445
R3262 spike_neg.n540 spike_neg.n539 0.1445
R3263 spike_neg.n539 spike_neg.n538 0.1445
R3264 spike_neg.n538 spike_neg.n56 0.1445
R3265 spike_neg.n534 spike_neg.n56 0.1445
R3266 spike_neg.n534 spike_neg.n533 0.1445
R3267 spike_neg.n533 spike_neg.n532 0.1445
R3268 spike_neg.n595 spike_neg.n2 0.107176
R3269 spike_neg.n570 Vss 0.0905
R3270 Vss spike_neg.n596 0.0905
R3271 spike_neg.n566 spike_neg.n29 0.0725
R3272 spike_neg.n497 spike_neg.n29 0.0725
R3273 spike_neg.n496 spike_neg.n452 0.0725
R3274 spike_neg.n489 spike_neg.n452 0.0725
R3275 spike_neg.n488 spike_neg.n461 0.0725
R3276 spike_neg.n475 spike_neg.n461 0.0725
R3277 spike_neg.n544 spike_neg.n543 0.0718661
R3278 spike_neg.n543 spike_neg.n542 0.0718661
R3279 spike_neg.n540 spike_neg.n2 0.0671
R3280 spike_neg.n52 spike_neg.n2 0.0599
R3281 spike_neg.n570 Vss 0.023
R3282 spike_neg.n596 Vss 0.023
R3283 spike_neg.n487 spike_neg.n486 0.0102035
R3284 spike_neg.n486 spike_neg.n463 0.0102035
R3285 spike_neg.n474 spike_neg.n463 0.0102035
R3286 spike_neg.n476 spike_neg.n474 0.0102035
R3287 spike_neg.n565 spike_neg.n564 0.0102035
R3288 spike_neg.n564 spike_neg.n31 0.0102035
R3289 spike_neg.n451 spike_neg.n31 0.0102035
R3290 spike_neg.n498 spike_neg.n451 0.0102035
R3291 spike_neg.n495 spike_neg.n494 0.0102035
R3292 spike_neg.n494 spike_neg.n453 0.0102035
R3293 spike_neg.n491 spike_neg.n453 0.0102035
R3294 spike_neg.n491 spike_neg.n490 0.0102035
R3295 spike_neg.n319 spike_neg.n25 0.005
R3296 spike_neg.n322 spike_neg.n319 0.005
R3297 spike_neg.n322 spike_neg.n321 0.005
R3298 spike_neg.n321 spike_neg.n320 0.005
R3299 spike_neg.n320 spike_neg.n147 0.005
R3300 spike_neg.n345 spike_neg.n147 0.005
R3301 spike_neg.n348 spike_neg.n345 0.005
R3302 spike_neg.n348 spike_neg.n347 0.005
R3303 spike_neg.n347 spike_neg.n346 0.005
R3304 spike_neg.n346 spike_neg.n126 0.005
R3305 spike_neg.n371 spike_neg.n126 0.005
R3306 spike_neg.n374 spike_neg.n371 0.005
R3307 spike_neg.n374 spike_neg.n373 0.005
R3308 spike_neg.n373 spike_neg.n372 0.005
R3309 spike_neg.n372 spike_neg.n106 0.005
R3310 spike_neg.n397 spike_neg.n106 0.005
R3311 spike_neg.n402 spike_neg.n397 0.005
R3312 spike_neg.n402 spike_neg.n401 0.005
R3313 spike_neg.n401 spike_neg.n400 0.005
R3314 spike_neg.n400 spike_neg.n399 0.005
R3315 spike_neg.n399 spike_neg.n398 0.005
R3316 spike_neg.n308 spike_neg.n28 0.00397994
R3317 spike_neg.n425 spike_neg.n74 0.00397994
R3318 spike_neg.n515 spike_neg.n74 0.00397994
R3319 spike_neg.n308 spike_neg.n166 0.00324045
R3320 spike_neg.n318 spike_neg.n317 0.00324045
R3321 spike_neg.n323 spike_neg.n165 0.00324045
R3322 spike_neg.n324 spike_neg.n159 0.00324045
R3323 spike_neg.n331 spike_neg.n157 0.00324045
R3324 spike_neg.n334 spike_neg.n148 0.00324045
R3325 spike_neg.n344 spike_neg.n343 0.00324045
R3326 spike_neg.n349 spike_neg.n146 0.00324045
R3327 spike_neg.n350 spike_neg.n140 0.00324045
R3328 spike_neg.n357 spike_neg.n138 0.00324045
R3329 spike_neg.n360 spike_neg.n127 0.00324045
R3330 spike_neg.n370 spike_neg.n369 0.00324045
R3331 spike_neg.n375 spike_neg.n125 0.00324045
R3332 spike_neg.n376 spike_neg.n119 0.00324045
R3333 spike_neg.n383 spike_neg.n117 0.00324045
R3334 spike_neg.n386 spike_neg.n107 0.00324045
R3335 spike_neg.n396 spike_neg.n395 0.00324045
R3336 spike_neg.n403 spike_neg.n105 0.00324045
R3337 spike_neg.n404 spike_neg.n99 0.00324045
R3338 spike_neg.n411 spike_neg.n97 0.00324045
R3339 spike_neg.n414 spike_neg.n90 0.00324045
R3340 spike_neg.n417 spike_neg.n91 0.00324045
R3341 spike_neg.n92 spike_neg.n82 0.00324045
R3342 spike_neg.n568 spike_neg.n567 0.00158748
R3343 spike_neg.n317 spike_neg.n166 0.00123949
R3344 spike_neg.n318 spike_neg.n165 0.00123949
R3345 spike_neg.n324 spike_neg.n323 0.00123949
R3346 spike_neg.n331 spike_neg.n159 0.00123949
R3347 spike_neg.n334 spike_neg.n157 0.00123949
R3348 spike_neg.n343 spike_neg.n148 0.00123949
R3349 spike_neg.n344 spike_neg.n146 0.00123949
R3350 spike_neg.n350 spike_neg.n349 0.00123949
R3351 spike_neg.n357 spike_neg.n140 0.00123949
R3352 spike_neg.n360 spike_neg.n138 0.00123949
R3353 spike_neg.n369 spike_neg.n127 0.00123949
R3354 spike_neg.n370 spike_neg.n125 0.00123949
R3355 spike_neg.n376 spike_neg.n375 0.00123949
R3356 spike_neg.n383 spike_neg.n119 0.00123949
R3357 spike_neg.n386 spike_neg.n117 0.00123949
R3358 spike_neg.n395 spike_neg.n107 0.00123949
R3359 spike_neg.n396 spike_neg.n105 0.00123949
R3360 spike_neg.n404 spike_neg.n403 0.00123949
R3361 spike_neg.n411 spike_neg.n99 0.00123949
R3362 spike_neg.n414 spike_neg.n97 0.00123949
R3363 spike_neg.n417 spike_neg.n90 0.00123949
R3364 spike_neg.n92 spike_neg.n91 0.00123949
R3365 spike_neg.n425 spike_neg.n82 0.00123949
R3366 spike_neg.n567 spike_neg.n28 0.00102199
R3367 spike_neg.n515 spike_neg.n75 0.000630498
C0 Vdd spike 0.43467f
C1 spike Unnamed_2af03fd8_2/a_64_n131# 0.6593f
C2 Vdd Unnamed_2af03fd8_2/a_64_n131# 0.58184f
C3 Unnamed_2af03fd8_2/a_n64_n339# Vdd 0.11794f
C4 Unnamed_2af03fd8_2/a_n64_n339# Unnamed_2af03fd8_2/a_64_n131# 0.72052f
C5 spike_neg.n0 Vss 0.00434f
C6 spike_neg.n1 Vss 0.00255f
C7 spike_neg.n2 Vss 0.02266f
C8 spike_neg.n3 Vss 0
C9 spike_neg.n4 Vss 0.00146f
C10 spike_neg.n5 Vss 0.01371f
C11 spike_neg.n6 Vss 0
C12 spike_neg.n7 Vss 0
C13 spike_neg.n8 Vss 0.00789f
C14 spike_neg.n9 Vss 0
C15 spike_neg.n10 Vss 0
C16 spike_neg.n11 Vss 0
C17 spike_neg.n12 Vss 0
C18 spike_neg.n13 Vss 0
C19 spike_neg.n14 Vss 0
C20 spike_neg.n15 Vss 0
C21 spike_neg.n16 Vss 0
C22 spike_neg.n17 Vss 0
C23 spike_neg.n18 Vss 0
C24 spike_neg.n19 Vss 0
C25 spike_neg.n20 Vss 0
C26 spike_neg.n21 Vss 0
C27 spike_neg.n22 Vss 0.00106f
C28 spike_neg.n23 Vss 0.00205f
C29 spike_neg.n24 Vss 0
C30 spike_neg.n25 Vss 0.05325f
C31 spike_neg.n26 Vss 0.00238f
C32 spike_neg.n27 Vss 0.02708f
C33 spike_neg.n28 Vss 0.01061f
C34 spike_neg.n29 Vss 0
C35 spike_neg.n30 Vss 0.00256f
C36 spike_neg.n31 Vss 0.00163f
C37 spike_neg.n32 Vss 0
C38 spike_neg.n33 Vss 0.00146f
C39 spike_neg.n34 Vss 0
C40 spike_neg.n35 Vss 0.00868f
C41 spike_neg.n36 Vss 0
C42 spike_neg.n37 Vss 0
C43 spike_neg.n38 Vss 0.00789f
C44 spike_neg.n39 Vss 0
C45 spike_neg.n40 Vss 0
C46 spike_neg.n41 Vss 0
C47 spike_neg.n42 Vss 0
C48 spike_neg.n43 Vss 0
C49 spike_neg.n44 Vss 0
C50 spike_neg.n45 Vss 0
C51 spike_neg.n46 Vss 0
C52 spike_neg.n47 Vss 0.01096f
C53 spike_neg.n48 Vss 0
C54 spike_neg.n49 Vss 0
C55 spike_neg.n50 Vss 0
C56 spike_neg.n51 Vss 0
C57 spike_neg.n52 Vss 0
C58 spike_neg.n53 Vss 0
C59 spike_neg.n54 Vss 0
C60 spike_neg.n55 Vss 0
C61 spike_neg.n56 Vss 0
C62 spike_neg.n57 Vss 0
C63 spike_neg.n58 Vss 0
C64 spike_neg.n59 Vss 0
C65 spike_neg.n60 Vss 0
C66 spike_neg.n61 Vss 0.00178f
C67 spike_neg.n62 Vss 0
C68 spike_neg.n63 Vss 0.00175f
C69 spike_neg.n64 Vss 0.00789f
C70 spike_neg.n65 Vss 0.00146f
C71 spike_neg.n66 Vss 0.01096f
C72 spike_neg.n67 Vss 0.02164f
C73 spike_neg.n68 Vss 0
C74 spike_neg.n69 Vss 0.00789f
C75 spike_neg.n70 Vss 0
C76 spike_neg.n71 Vss 0
C77 spike_neg.n72 Vss 0
C78 spike_neg.n73 Vss 0
C79 spike_neg.n74 Vss 0.01833f
C80 spike_neg.n75 Vss 0.00119f
C81 spike_neg.n76 Vss 0.00208f
C82 spike_neg.n77 Vss 0
C83 spike_neg.n78 Vss 0
C84 spike_neg.n79 Vss 0.02421f
C85 spike_neg.n80 Vss 0
C86 spike_neg.n81 Vss 0
C87 spike_neg.n82 Vss 0.0098f
C88 spike_neg.n83 Vss 0.00101f
C89 spike_neg.n84 Vss 0.00101f
C90 spike_neg.n85 Vss 0
C91 spike_neg.n86 Vss 0
C92 spike_neg.n87 Vss 0.02421f
C93 spike_neg.n88 Vss 0
C94 spike_neg.n89 Vss 0
C95 spike_neg.n90 Vss 0.00908f
C96 spike_neg.n91 Vss 0.00908f
C97 spike_neg.n92 Vss 0.00925f
C98 spike_neg.n93 Vss 0.00101f
C99 spike_neg.n94 Vss 0.00101f
C100 spike_neg.n95 Vss 0
C101 spike_neg.n96 Vss 0
C102 spike_neg.n97 Vss 0.00908f
C103 spike_neg.n98 Vss 0.00101f
C104 spike_neg.n99 Vss 0.00908f
C105 spike_neg.n100 Vss 0
C106 spike_neg.n101 Vss 0
C107 spike_neg.n102 Vss 0.02421f
C108 spike_neg.n103 Vss 0
C109 spike_neg.n104 Vss 0
C110 spike_neg.n105 Vss 0.00925f
C111 spike_neg.n106 Vss 0.01404f
C112 spike_neg.n107 Vss 0.00908f
C113 spike_neg.n108 Vss 0
C114 spike_neg.n109 Vss 0.00101f
C115 spike_neg.n110 Vss 0.00101f
C116 spike_neg.n111 Vss 0
C117 spike_neg.n112 Vss 0
C118 spike_neg.n113 Vss 0.02421f
C119 spike_neg.n114 Vss 0.02421f
C120 spike_neg.n115 Vss 0
C121 spike_neg.n116 Vss 0
C122 spike_neg.n117 Vss 0.00908f
C123 spike_neg.n118 Vss 0
C124 spike_neg.n119 Vss 0.00908f
C125 spike_neg.n120 Vss 0
C126 spike_neg.n121 Vss 0
C127 spike_neg.n122 Vss 0.02421f
C128 spike_neg.n123 Vss 0
C129 spike_neg.n124 Vss 0
C130 spike_neg.n125 Vss 0.00925f
C131 spike_neg.n126 Vss 0.01404f
C132 spike_neg.n127 Vss 0.00908f
C133 spike_neg.n128 Vss 0
C134 spike_neg.n129 Vss 0.08144f
C135 spike_neg.n130 Vss 0.03199f
C136 spike_neg.n131 Vss 0
C137 spike_neg.n132 Vss 0.00101f
C138 spike_neg.n133 Vss 0
C139 spike_neg.n134 Vss 0
C140 spike_neg.n135 Vss 0.02421f
C141 spike_neg.n136 Vss 0
C142 spike_neg.n137 Vss 0
C143 spike_neg.n138 Vss 0.00908f
C144 spike_neg.n139 Vss 0.00101f
C145 spike_neg.n140 Vss 0.00908f
C146 spike_neg.n141 Vss 0
C147 spike_neg.n142 Vss 0
C148 spike_neg.n143 Vss 0.02421f
C149 spike_neg.n144 Vss 0
C150 spike_neg.n145 Vss 0
C151 spike_neg.n146 Vss 0.00925f
C152 spike_neg.n147 Vss 0.01404f
C153 spike_neg.n148 Vss 0.00908f
C154 spike_neg.n149 Vss 0
C155 spike_neg.n150 Vss 0.00101f
C156 spike_neg.n151 Vss 0.00101f
C157 spike_neg.n152 Vss 0
C158 spike_neg.n153 Vss 0
C159 spike_neg.n154 Vss 0.02421f
C160 spike_neg.n155 Vss 0
C161 spike_neg.n156 Vss 0
C162 spike_neg.n157 Vss 0.00908f
C163 spike_neg.n158 Vss 0.00101f
C164 spike_neg.n159 Vss 0.00908f
C165 spike_neg.n160 Vss 0
C166 spike_neg.n161 Vss 0
C167 spike_neg.n162 Vss 0.02421f
C168 spike_neg.n163 Vss 0
C169 spike_neg.n164 Vss 0
C170 spike_neg.n165 Vss 0.00925f
C171 spike_neg.n166 Vss 0.00908f
C172 spike_neg.n167 Vss 0
C173 spike_neg.n168 Vss 0.00101f
C174 spike_neg.n169 Vss 0.00101f
C175 spike_neg.n170 Vss 0
C176 spike_neg.n171 Vss 0
C177 spike_neg.n172 Vss 0.02421f
C178 spike_neg.n173 Vss 0
C179 spike_neg.n174 Vss 0
C180 spike_neg.n175 Vss 0
C181 spike_neg.n176 Vss 0.02421f
C182 spike_neg.n177 Vss 0
C183 spike_neg.n178 Vss 0
C184 spike_neg.n179 Vss 0
C185 spike_neg.n180 Vss 0
C186 spike_neg.n181 Vss 0
C187 spike_neg.n182 Vss 0
C188 spike_neg.n183 Vss 0.02421f
C189 spike_neg.n184 Vss 0
C190 spike_neg.n185 Vss 0
C191 spike_neg.n186 Vss 0
C192 spike_neg.n187 Vss 0
C193 spike_neg.n188 Vss 0
C194 spike_neg.n189 Vss 0.02421f
C195 spike_neg.n190 Vss 0
C196 spike_neg.n191 Vss 0
C197 spike_neg.n192 Vss 0
C198 spike_neg.n193 Vss 0
C199 spike_neg.n194 Vss 0
C200 spike_neg.n195 Vss 0.02421f
C201 spike_neg.n196 Vss 0
C202 spike_neg.n197 Vss 0
C203 spike_neg.n198 Vss 0
C204 spike_neg.n199 Vss 0
C205 spike_neg.n200 Vss 0
C206 spike_neg.n201 Vss 0.02421f
C207 spike_neg.n202 Vss 0
C208 spike_neg.n203 Vss 0
C209 spike_neg.n204 Vss 0
C210 spike_neg.n205 Vss 0
C211 spike_neg.n206 Vss 0
C212 spike_neg.n207 Vss 0.02421f
C213 spike_neg.n208 Vss 0
C214 spike_neg.n209 Vss 0
C215 spike_neg.n210 Vss 0
C216 spike_neg.n211 Vss 0
C217 spike_neg.n212 Vss 0
C218 spike_neg.n213 Vss 0.02421f
C219 spike_neg.n214 Vss 0
C220 spike_neg.n215 Vss 0
C221 spike_neg.n216 Vss 0
C222 spike_neg.n217 Vss 0
C223 spike_neg.n218 Vss 0
C224 spike_neg.n219 Vss 0.02421f
C225 spike_neg.n220 Vss 0
C226 spike_neg.n221 Vss 0
C227 spike_neg.n222 Vss 0.00114f
C228 spike_neg.n223 Vss 0
C229 spike_neg.n224 Vss 0.00106f
C230 spike_neg.n225 Vss 0.03162f
C231 spike_neg.n226 Vss 0.00106f
C232 spike_neg.n227 Vss 0
C233 spike_neg.n229 Vss 0.09511f
C234 spike_neg.n230 Vss 0.00337f
C235 spike_neg.n231 Vss 0.00114f
C236 spike_neg.n232 Vss 0
C237 spike_neg.n233 Vss 0
C238 spike_neg.n234 Vss 0
C239 spike_neg.n235 Vss 0.02421f
C240 spike_neg.n236 Vss 0
C241 spike_neg.n237 Vss 0
C242 spike_neg.n238 Vss 0
C243 spike_neg.n239 Vss 0
C244 spike_neg.n240 Vss 0
C245 spike_neg.n241 Vss 0
C246 spike_neg.n242 Vss 0
C247 spike_neg.n243 Vss 0.02421f
C248 spike_neg.n244 Vss 0
C249 spike_neg.n245 Vss 0
C250 spike_neg.n246 Vss 0
C251 spike_neg.n247 Vss 0
C252 spike_neg.n248 Vss 0
C253 spike_neg.n249 Vss 0
C254 spike_neg.n250 Vss 0
C255 spike_neg.n251 Vss 0.02421f
C256 spike_neg.n252 Vss 0
C257 spike_neg.n253 Vss 0
C258 spike_neg.n254 Vss 0
C259 spike_neg.n255 Vss 0
C260 spike_neg.n256 Vss 0
C261 spike_neg.n257 Vss 0
C262 spike_neg.n258 Vss 0
C263 spike_neg.n259 Vss 0.02421f
C264 spike_neg.n260 Vss 0
C265 spike_neg.n261 Vss 0
C266 spike_neg.n262 Vss 0
C267 spike_neg.n263 Vss 0
C268 spike_neg.n264 Vss 0
C269 spike_neg.n265 Vss 0
C270 spike_neg.n266 Vss 0
C271 spike_neg.n267 Vss 0.02421f
C272 spike_neg.n268 Vss 0
C273 spike_neg.n269 Vss 0
C274 spike_neg.n270 Vss 0
C275 spike_neg.n271 Vss 0
C276 spike_neg.n272 Vss 0
C277 spike_neg.n273 Vss 0
C278 spike_neg.n274 Vss 0
C279 spike_neg.n275 Vss 0.02421f
C280 spike_neg.n276 Vss 0
C281 spike_neg.n277 Vss 0
C282 spike_neg.n278 Vss 0
C283 spike_neg.n279 Vss 0
C284 spike_neg.n280 Vss 0
C285 spike_neg.n281 Vss 0
C286 spike_neg.n282 Vss 0
C287 spike_neg.n283 Vss 0.02421f
C288 spike_neg.n284 Vss 0
C289 spike_neg.n285 Vss 0
C290 spike_neg.n286 Vss 0
C291 spike_neg.n287 Vss 0
C292 spike_neg.n288 Vss 0
C293 spike_neg.n289 Vss 0
C294 spike_neg.n290 Vss 0
C295 spike_neg.n291 Vss 0
C296 spike_neg.n292 Vss 0.02421f
C297 spike_neg.n293 Vss 0
C298 spike_neg.n294 Vss 0
C299 spike_neg.n295 Vss 0
C300 spike_neg.n296 Vss 0
C301 spike_neg.n297 Vss 0.00255f
C302 spike_neg.n298 Vss 0
C303 spike_neg.n299 Vss 0
C304 spike_neg.n300 Vss 0
C305 spike_neg.n301 Vss 0.02421f
C306 spike_neg.n302 Vss 0.02421f
C307 spike_neg.n303 Vss 0
C308 spike_neg.n304 Vss 0
C309 spike_neg.n305 Vss 0
C310 spike_neg.n306 Vss 0.00243f
C311 spike_neg.n307 Vss 0.00101f
C312 spike_neg.n308 Vss 0.0164f
C313 spike_neg.n309 Vss 0
C314 spike_neg.n310 Vss 0
C315 spike_neg.n311 Vss 0
C316 spike_neg.n312 Vss 0.02421f
C317 spike_neg.n313 Vss 0
C318 spike_neg.n314 Vss 0
C319 spike_neg.n315 Vss 0
C320 spike_neg.n316 Vss 0
C321 spike_neg.n317 Vss 0.00925f
C322 spike_neg.n318 Vss 0.00908f
C323 spike_neg.n319 Vss 0.01404f
C324 spike_neg.n320 Vss 0.01404f
C325 spike_neg.n321 Vss 0.01404f
C326 spike_neg.n322 Vss 0.01404f
C327 spike_neg.n323 Vss 0.00908f
C328 spike_neg.n324 Vss 0.00925f
C329 spike_neg.n325 Vss 0
C330 spike_neg.n326 Vss 0
C331 spike_neg.n327 Vss 0.02421f
C332 spike_neg.n328 Vss 0.02421f
C333 spike_neg.n329 Vss 0
C334 spike_neg.n330 Vss 0
C335 spike_neg.n331 Vss 0.00925f
C336 spike_neg.n332 Vss 0.00101f
C337 spike_neg.n333 Vss 0.00101f
C338 spike_neg.n334 Vss 0.00925f
C339 spike_neg.n335 Vss 0
C340 spike_neg.n336 Vss 0
C341 spike_neg.n337 Vss 0
C342 spike_neg.n338 Vss 0.02421f
C343 spike_neg.n339 Vss 0
C344 spike_neg.n340 Vss 0
C345 spike_neg.n341 Vss 0
C346 spike_neg.n342 Vss 0
C347 spike_neg.n343 Vss 0.00925f
C348 spike_neg.n344 Vss 0.00908f
C349 spike_neg.n345 Vss 0.01404f
C350 spike_neg.n346 Vss 0.01404f
C351 spike_neg.n347 Vss 0.01404f
C352 spike_neg.n348 Vss 0.01404f
C353 spike_neg.n349 Vss 0.00908f
C354 spike_neg.n350 Vss 0.00925f
C355 spike_neg.n351 Vss 0
C356 spike_neg.n352 Vss 0
C357 spike_neg.n353 Vss 0.02421f
C358 spike_neg.n354 Vss 0.02421f
C359 spike_neg.n355 Vss 0
C360 spike_neg.n356 Vss 0
C361 spike_neg.n357 Vss 0.00925f
C362 spike_neg.n358 Vss 0.00101f
C363 spike_neg.n359 Vss 0.00101f
C364 spike_neg.n360 Vss 0.00925f
C365 spike_neg.n361 Vss 0
C366 spike_neg.n362 Vss 0
C367 spike_neg.n363 Vss 0
C368 spike_neg.n364 Vss 0.02421f
C369 spike_neg.n365 Vss 0
C370 spike_neg.n366 Vss 0
C371 spike_neg.n367 Vss 0
C372 spike_neg.n368 Vss 0
C373 spike_neg.n369 Vss 0.00925f
C374 spike_neg.n370 Vss 0.00908f
C375 spike_neg.n371 Vss 0.01404f
C376 spike_neg.n372 Vss 0.01404f
C377 spike_neg.n373 Vss 0.01404f
C378 spike_neg.n374 Vss 0.01404f
C379 spike_neg.n375 Vss 0.00908f
C380 spike_neg.n376 Vss 0.00925f
C381 spike_neg.n377 Vss 0
C382 spike_neg.n378 Vss 0
C383 spike_neg.n379 Vss 0.02421f
C384 spike_neg.n380 Vss 0.02421f
C385 spike_neg.n381 Vss 0
C386 spike_neg.n382 Vss 0
C387 spike_neg.n383 Vss 0.00925f
C388 spike_neg.n384 Vss 0.00101f
C389 spike_neg.n385 Vss 0.00101f
C390 spike_neg.n386 Vss 0.00925f
C391 spike_neg.n387 Vss 0
C392 spike_neg.n388 Vss 0
C393 spike_neg.n389 Vss 0
C394 spike_neg.n390 Vss 0
C395 spike_neg.n391 Vss 0
C396 spike_neg.n392 Vss 0.02421f
C397 spike_neg.n393 Vss 0
C398 spike_neg.n394 Vss 0
C399 spike_neg.n395 Vss 0.00925f
C400 spike_neg.n396 Vss 0.00908f
C401 spike_neg.n397 Vss 0.01404f
C402 spike_neg.n398 Vss 0.05895f
C403 spike_neg.n399 Vss 0.01404f
C404 spike_neg.n400 Vss 0.01404f
C405 spike_neg.n401 Vss 0.01404f
C406 spike_neg.n402 Vss 0.01404f
C407 spike_neg.n403 Vss 0.00908f
C408 spike_neg.n404 Vss 0.00925f
C409 spike_neg.n405 Vss 0
C410 spike_neg.n406 Vss 0
C411 spike_neg.n407 Vss 0
C412 spike_neg.n408 Vss 0.02421f
C413 spike_neg.n409 Vss 0
C414 spike_neg.n410 Vss 0
C415 spike_neg.n411 Vss 0.00925f
C416 spike_neg.n412 Vss 0.00101f
C417 spike_neg.n413 Vss 0.00101f
C418 spike_neg.n414 Vss 0.00925f
C419 spike_neg.n415 Vss 0
C420 spike_neg.n416 Vss 0
C421 spike_neg.n417 Vss 0.00925f
C422 spike_neg.n418 Vss 0
C423 spike_neg.n419 Vss 0
C424 spike_neg.n420 Vss 0.02421f
C425 spike_neg.n421 Vss 0.02421f
C426 spike_neg.n422 Vss 0
C427 spike_neg.n423 Vss 0
C428 spike_neg.n424 Vss 0
C429 spike_neg.n425 Vss 0.01118f
C430 spike_neg.n426 Vss 0
C431 spike_neg.n427 Vss 0
C432 spike_neg.n428 Vss 0
C433 spike_neg.n429 Vss 0.02421f
C434 spike_neg.n430 Vss 0.02421f
C435 spike_neg.n431 Vss 0
C436 spike_neg.n432 Vss 0.00822f
C437 spike_neg.n433 Vss 0.00218f
C438 spike_neg.n434 Vss 0.00218f
C439 spike_neg.n435 Vss 0
C440 spike_neg.n436 Vss 0
C441 spike_neg.n437 Vss 0
C442 spike_neg.n438 Vss 0
C443 spike_neg.n439 Vss 0
C444 spike_neg.n440 Vss 0
C445 spike_neg.n441 Vss 0
C446 spike_neg.n442 Vss 0
C447 spike_neg.n443 Vss 0
C448 spike_neg.n444 Vss 0.00819f
C449 spike_neg.n445 Vss 0.00918f
C450 spike_neg.n446 Vss 0
C451 spike_neg.n447 Vss 0.00115f
C452 spike_neg.n448 Vss 0
C453 spike_neg.n449 Vss 0
C454 spike_neg.n450 Vss 0.00119f
C455 spike_neg.n451 Vss 0.00163f
C456 spike_neg.n452 Vss 0
C457 spike_neg.n453 Vss 0.00163f
C458 spike_neg.n454 Vss 0.00809f
C459 spike_neg.n455 Vss 0.01352f
C460 spike_neg.n456 Vss 0
C461 spike_neg.n457 Vss 0.00947f
C462 spike_neg.n458 Vss 0.00789f
C463 spike_neg.n459 Vss 0.00146f
C464 spike_neg.n460 Vss 0
C465 spike_neg.n461 Vss 0
C466 spike_neg.n462 Vss 0.00256f
C467 spike_neg.n463 Vss 0.00163f
C468 spike_neg.n464 Vss 0
C469 spike_neg.n465 Vss 0.00146f
C470 spike_neg.n466 Vss 0
C471 spike_neg.n467 Vss 0.00858f
C472 spike_neg.n468 Vss 0
C473 spike_neg.n469 Vss 0.00878f
C474 spike_neg.n470 Vss 0.00789f
C475 spike_neg.n471 Vss 0.01371f
C476 spike_neg.n472 Vss 0
C477 spike_neg.n473 Vss 0.00115f
C478 spike_neg.n474 Vss 0.00163f
C479 spike_neg.n475 Vss 0.00853f
C480 spike_neg.n476 Vss 0.00439f
C481 spike_neg.n477 Vss 0.00436f
C482 spike_neg.n478 Vss 0.00119f
C483 spike_neg.n479 Vss 0
C484 spike_neg.n480 Vss 0
C485 spike_neg.n481 Vss 0
C486 spike_neg.n482 Vss 0.00789f
C487 spike_neg.n483 Vss 0.00789f
C488 spike_neg.n484 Vss 0
C489 spike_neg.n485 Vss 0
C490 spike_neg.n486 Vss 0.00163f
C491 spike_neg.n487 Vss 0.00439f
C492 spike_neg.n488 Vss 0.00258f
C493 spike_neg.n489 Vss 0.00258f
C494 spike_neg.n490 Vss 0.00439f
C495 spike_neg.n491 Vss 0.00163f
C496 spike_neg.n492 Vss 0
C497 spike_neg.n493 Vss 0
C498 spike_neg.n494 Vss 0.00163f
C499 spike_neg.n495 Vss 0.00439f
C500 spike_neg.n496 Vss 0.00258f
C501 spike_neg.n497 Vss 0.00258f
C502 spike_neg.n498 Vss 0.00439f
C503 spike_neg.n499 Vss 0.00436f
C504 spike_neg.n500 Vss 0.00146f
C505 spike_neg.n501 Vss 0.00789f
C506 spike_neg.n502 Vss 0.01371f
C507 spike_neg.n503 Vss 0
C508 spike_neg.n504 Vss 0
C509 spike_neg.n505 Vss 0
C510 spike_neg.n506 Vss 0
C511 spike_neg.n507 Vss 0
C512 spike_neg.n508 Vss 0.01292f
C513 spike_neg.n509 Vss 0
C514 spike_neg.n510 Vss 0
C515 spike_neg.n511 Vss 0
C516 spike_neg.n512 Vss 0
C517 spike_neg.n513 Vss 0
C518 spike_neg.n514 Vss 0
C519 spike_neg.n515 Vss 0.00959f
C520 spike_neg.n516 Vss 0
C521 spike_neg.n517 Vss 0
C522 spike_neg.n518 Vss 0
C523 spike_neg.n519 Vss -0
C524 spike_neg.n520 Vss 0
C525 spike_neg.n521 Vss 0
C526 spike_neg.n522 Vss 0
C527 spike_neg.n523 Vss 0
C528 spike_neg.n524 Vss 0.00454f
C529 spike_neg.n525 Vss 0.02218f
C530 spike_neg.n526 Vss 0.0261f
C531 spike_neg.n527 Vss 0.04462f
C532 spike_neg.n528 Vss 0.07458f
C533 spike_neg.n529 Vss 0.01371f
C534 spike_neg.n530 Vss 0.00106f
C535 spike_neg.n531 Vss 0
C536 spike_neg.n532 Vss 0
C537 spike_neg.n533 Vss 0
C538 spike_neg.n534 Vss 0
C539 spike_neg.n535 Vss 0
C540 spike_neg.n536 Vss 0
C541 spike_neg.n537 Vss 0
C542 spike_neg.n538 Vss 0
C543 spike_neg.n539 Vss 0
C544 spike_neg.n540 Vss 0
C545 spike_neg.n541 Vss 0
C546 spike_neg.n542 Vss 0
C547 spike_neg.n544 Vss 0
C548 spike_neg.n545 Vss 0
C549 spike_neg.n546 Vss 0
C550 spike_neg.n547 Vss 0
C551 spike_neg.n548 Vss 0.00789f
C552 spike_neg.n549 Vss 0.00947f
C553 spike_neg.n550 Vss 0
C554 spike_neg.n551 Vss 0
C555 spike_neg.n552 Vss 0
C556 spike_neg.n553 Vss 0
C557 spike_neg.n554 Vss 0
C558 spike_neg.n555 Vss 0
C559 spike_neg.n556 Vss 0
C560 spike_neg.n557 Vss 0
C561 spike_neg.n558 Vss 0
C562 spike_neg.n559 Vss 0
C563 spike_neg.n560 Vss 0.00789f
C564 spike_neg.n561 Vss 0.00789f
C565 spike_neg.n562 Vss 0
C566 spike_neg.n563 Vss 0
C567 spike_neg.n564 Vss 0.00163f
C568 spike_neg.n565 Vss 0.00439f
C569 spike_neg.n566 Vss 0.0075f
C570 spike_neg.n567 Vss 0.00868f
C571 spike_neg.n568 Vss 0.00146f
C572 spike_neg.n569 Vss -0.00109f
C573 spike_neg.n570 Vss 0.00106f
C574 spike_neg.n571 Vss 0.00376f
C575 spike_neg.n572 Vss 0.00431f
C576 spike_neg.n573 Vss 0.00616f
C577 spike_neg.n574 Vss 0.00594f
C578 spike_neg.n575 Vss 0.00142f
C579 spike_neg.n576 Vss 0.00106f
C580 spike_neg.n577 Vss 0
C581 spike_neg.n578 Vss 0
C582 spike_neg.n579 Vss 0
C583 spike_neg.n580 Vss 0
C584 spike_neg.n581 Vss 0
C585 spike_neg.n582 Vss 0
C586 spike_neg.n583 Vss 0
C587 spike_neg.n584 Vss 0
C588 spike_neg.n585 Vss 0
C589 spike_neg.n586 Vss 0
C590 spike_neg.n587 Vss 0
C591 spike_neg.n588 Vss 0
C592 spike_neg.n589 Vss 0
C593 spike_neg.n590 Vss 0
C594 spike_neg.n591 Vss 0.00789f
C595 spike_neg.n592 Vss 0.00789f
C596 spike_neg.n593 Vss 0
C597 spike_neg.n594 Vss 0
C598 spike_neg.n595 Vss 0.01284f
C599 spike_neg.n596 Vss 0.00567f
C600 Iin.n0 Vss 0
C601 Iin.n1 Vss 0
C602 Iin.n2 Vss 0.00128f
C603 Iin.n3 Vss 0
C604 Iin.n4 Vss 0
C605 Iin.n5 Vss 0
C606 Iin.n6 Vss 0
C607 Iin.n7 Vss 0.00156f
C608 Iin.n8 Vss 0
C609 Iin.n9 Vss 0
C610 Iin.n10 Vss 0.00356f
C611 Iin.n11 Vss 0.00356f
C612 Iin.n12 Vss 0
C613 Iin.n13 Vss 0
C614 Iin.n14 Vss 0
C615 Iin.n15 Vss 0
C616 Iin.n16 Vss 0
C617 Iin.n17 Vss 0
C618 Iin.n18 Vss 0
C619 Iin.n19 Vss 0
C620 Iin.n20 Vss 0.00356f
C621 Iin.n21 Vss 0
C622 Iin.n22 Vss 0
C623 Iin.n23 Vss 0
C624 Iin.n24 Vss 0
C625 Iin.n25 Vss 0
C626 Iin.n26 Vss 0.00356f
C627 Iin.n27 Vss 0
C628 Iin.n28 Vss 0
C629 Iin.n29 Vss 0
C630 Iin.n30 Vss 0
C631 Iin.n31 Vss 0
C632 Iin.n32 Vss 0.00356f
C633 Iin.n33 Vss 0
C634 Iin.n34 Vss 0
C635 Iin.n35 Vss 0
C636 Iin.n36 Vss 0
C637 Iin.n37 Vss 0
C638 Iin.n38 Vss 0
C639 Iin.n39 Vss 0.00356f
C640 Iin.n40 Vss 0
C641 Iin.n41 Vss 0
C642 Iin.n42 Vss 0
C643 Iin.n43 Vss 0
C644 Iin.n44 Vss 0
C645 Iin.n45 Vss 0.00356f
C646 Iin.n46 Vss 0
C647 Iin.n47 Vss 0
C648 Iin.n48 Vss 0
C649 Iin.n49 Vss 0
C650 Iin.n50 Vss 0
C651 Iin.n51 Vss 0.00356f
C652 Iin.n52 Vss 0
C653 Iin.n53 Vss 0
C654 Iin.n54 Vss 0
C655 Iin.n55 Vss 0
C656 Iin.n56 Vss 0
C657 Iin.n57 Vss 0.00356f
C658 Iin.n58 Vss 0
C659 Iin.n59 Vss 0
C660 Iin.n60 Vss 0
C661 Iin.n61 Vss 0.014f
C662 Iin.n62 Vss 0
C663 Iin.n63 Vss 0
C664 Iin.n64 Vss 0
C665 Iin.n65 Vss 0.00465f
C666 Iin.n67 Vss 0
C667 Iin.n68 Vss 0
C668 Iin.n69 Vss 0
C669 Iin.n70 Vss 0
C670 Iin.n71 Vss 0
C671 Iin.n72 Vss 0
C672 Iin.n73 Vss 0
C673 Iin.n74 Vss 0.00356f
C674 Iin.n75 Vss 0
C675 Iin.n76 Vss 0
C676 Iin.n77 Vss 0
C677 Iin.n78 Vss 0
C678 Iin.n79 Vss 0
C679 Iin.n80 Vss 0
C680 Iin.n81 Vss 0
C681 Iin.n82 Vss 0.00356f
C682 Iin.n83 Vss 0
C683 Iin.n84 Vss 0
C684 Iin.n85 Vss 0
C685 Iin.n86 Vss 0
C686 Iin.n87 Vss 0
C687 Iin.n88 Vss 0
C688 Iin.n89 Vss 0
C689 Iin.n90 Vss 0.00356f
C690 Iin.n91 Vss 0
C691 Iin.n92 Vss 0
C692 Iin.n93 Vss 0
C693 Iin.n94 Vss 0
C694 Iin.n95 Vss 0
C695 Iin.n96 Vss 0
C696 Iin.n97 Vss 0
C697 Iin.n98 Vss 0.00356f
C698 Iin.n99 Vss 0
C699 Iin.n100 Vss 0
C700 Iin.n101 Vss 0
C701 Iin.n102 Vss 0
C702 Iin.n103 Vss 0
C703 Iin.n104 Vss 0
C704 Iin.n105 Vss 0
C705 Iin.n106 Vss 0
C706 Iin.n107 Vss 0.00356f
C707 Iin.n108 Vss 0
C708 Iin.n109 Vss 0
C709 Iin.n110 Vss 0
C710 Iin.n111 Vss 0
C711 Iin.n112 Vss 0
C712 Iin.n113 Vss 0
C713 Iin.n114 Vss 0
C714 Iin.n115 Vss 0.00356f
C715 Iin.n116 Vss 0
C716 Iin.n117 Vss 0
C717 Iin.n118 Vss 0
C718 Iin.n119 Vss 0
C719 Iin.n120 Vss 0
C720 Iin.n121 Vss 0
C721 Iin.n122 Vss 0
C722 Iin.n123 Vss 0
C723 Iin.n124 Vss 0
C724 Iin.n125 Vss 0.00356f
C725 Iin.n126 Vss 0.00356f
C726 Iin.n127 Vss 0.00356f
C727 Iin.n128 Vss 0
C728 Iin.n129 Vss 0
C729 Iin.n130 Vss 0
C730 Iin.n131 Vss 0
C731 Iin.n132 Vss 0
C732 Iin.n133 Vss 0
C733 Iin.n134 Vss 0
C734 Iin.n135 Vss 0
C735 Iin.n136 Vss 0.00134f
C736 Iin.n137 Vss 0
C737 Iin.n138 Vss 0
C738 Iin.n139 Vss 0.00136f
C739 Iin.n140 Vss 0.00784f
C740 Iin.n141 Vss 0.00207f
C741 Iin.n142 Vss 0
C742 Iin.n143 Vss 0.00134f
C743 Iin.n144 Vss 0
C744 Iin.n145 Vss 0
C745 Iin.n146 Vss 0
C746 Iin.n147 Vss 0
C747 Iin.n148 Vss 0
C748 Iin.n149 Vss 0
C749 Iin.n150 Vss 0.00134f
C750 Iin.n151 Vss 0
C751 Iin.n152 Vss 0
C752 Iin.n153 Vss 0.00136f
C753 Iin.n154 Vss 0.00207f
C754 Iin.n155 Vss 0.00207f
C755 Iin.n156 Vss 0
C756 Iin.n157 Vss 0.00134f
C757 Iin.n158 Vss 0
C758 Iin.n159 Vss 0
C759 Iin.n160 Vss 0
C760 Iin.n161 Vss 0
C761 Iin.n162 Vss 0
C762 Iin.n163 Vss 0
C763 Iin.n164 Vss 0.00134f
C764 Iin.n165 Vss 0
C765 Iin.n166 Vss 0
C766 Iin.n167 Vss 0.00136f
C767 Iin.n168 Vss 0.00207f
C768 Iin.n169 Vss 0.00207f
C769 Iin.n170 Vss 0
C770 Iin.n171 Vss 0.00134f
C771 Iin.n172 Vss 0
C772 Iin.n173 Vss 0
C773 Iin.n174 Vss 0
C774 Iin.n175 Vss 0
C775 Iin.n176 Vss 0
C776 Iin.n177 Vss 0
C777 Iin.n178 Vss 0.00134f
C778 Iin.n179 Vss 0.01199f
C779 Iin.n180 Vss 0
C780 Iin.n181 Vss 0
C781 Iin.n182 Vss 0.00136f
C782 Iin.n183 Vss 0.00207f
C783 Iin.n184 Vss 0.00207f
C784 Iin.n185 Vss 0
C785 Iin.n186 Vss 0.00134f
C786 Iin.n187 Vss 0
C787 Iin.n188 Vss 0
C788 Iin.n189 Vss 0
C789 Iin.n190 Vss 0
C790 Iin.n191 Vss 0
C791 Iin.n192 Vss 0
C792 Iin.n193 Vss 0.00134f
C793 Iin.n194 Vss 0
C794 Iin.n195 Vss 0
C795 Iin.n196 Vss 0.00136f
C796 Iin.n197 Vss 0.00207f
C797 Iin.n198 Vss 0.00207f
C798 Iin.n199 Vss 0
C799 Iin.n200 Vss 0.00134f
C800 Iin.n201 Vss 0
C801 Iin.n202 Vss 0
C802 Iin.n203 Vss 0
C803 Iin.n204 Vss 0
C804 Iin.n205 Vss 0
C805 Iin.n206 Vss 0
C806 Iin.n207 Vss 0.00134f
C807 Iin.n208 Vss 0
C808 Iin.n209 Vss 0
C809 Iin.n210 Vss 0.00136f
C810 Iin.n211 Vss 0.00207f
C811 Iin.n212 Vss 0
C812 Iin.n213 Vss 0.0027f
C813 Iin.n214 Vss 0
C814 Iin.n215 Vss 0
C815 Iin.n216 Vss 0
C816 Iin.n217 Vss 0
C817 Iin.n218 Vss 0
C818 Iin.n219 Vss 0
C819 Iin.n220 Vss 0
C820 Iin.n221 Vss 0
C821 Iin.n222 Vss 0
C822 Iin.n223 Vss 0.00333f
C823 Iin.n224 Vss 0
C824 Iin.n225 Vss 0
C825 Iin.n226 Vss 0
C826 Iin.n227 Vss 0
C827 Iin.n228 Vss 0.00326f
C828 Iin.n229 Vss 0.00116f
C829 Iin.n230 Vss 0.00356f
C830 Iin.n231 Vss 0
C831 Iin.n232 Vss 0
C832 Iin.n233 Vss 0.00356f
C833 Iin.n234 Vss 0
C834 Iin.n235 Vss 0
C835 Iin.n236 Vss 0.00356f
C836 Iin.n237 Vss 0
C837 Iin.n238 Vss 0
C838 Iin.n239 Vss 0.00356f
C839 Iin.n240 Vss 0
C840 Iin.n241 Vss 0
C841 Iin.n242 Vss 0.00356f
C842 Iin.n243 Vss 0
C843 Iin.n244 Vss 0
C844 Iin.n245 Vss 0.00356f
C845 Iin.n246 Vss 0
C846 Iin.n247 Vss 0
C847 Iin.n248 Vss 0
C848 Iin.n249 Vss 0.00356f
C849 Iin.n250 Vss 0
C850 Iin.n251 Vss 0
C851 Iin.n252 Vss 0.00356f
C852 Iin.n253 Vss 0.00356f
C853 Iin.n254 Vss 0
C854 Iin.n255 Vss 0
C855 Iin.n256 Vss 0
C856 Iin.n257 Vss 0.00356f
C857 Iin.n258 Vss 0
C858 Iin.n259 Vss 0
C859 Iin.n260 Vss 0.00356f
C860 Iin.n261 Vss 0.00356f
C861 Iin.n262 Vss 0
C862 Iin.n263 Vss 0
C863 Iin.n264 Vss 0
C864 Iin.n265 Vss 0.00356f
C865 Iin.n266 Vss 0
C866 Iin.n267 Vss 0
C867 Iin.n268 Vss 0.00356f
C868 Iin.n269 Vss 0.00356f
C869 Iin.n270 Vss 0
C870 Iin.n271 Vss 0
C871 Iin.n272 Vss 0
C872 Iin.n273 Vss 0.00356f
C873 Iin.n274 Vss 0
C874 Iin.n275 Vss 0
C875 Iin.n276 Vss 0.00356f
C876 Iin.n277 Vss 0.00356f
C877 Iin.n278 Vss 0
C878 Iin.n279 Vss 0
C879 Iin.n280 Vss 0
C880 Iin.n281 Vss 0.00356f
C881 Iin.n282 Vss 0
C882 Iin.n283 Vss 0
C883 Iin.n284 Vss 0.00356f
C884 Iin.n285 Vss 0.00356f
C885 Iin.n286 Vss 0
C886 Iin.n287 Vss 0
C887 Iin.n288 Vss 0
C888 Iin.n289 Vss 0.00356f
C889 Iin.n290 Vss 0
C890 Iin.n291 Vss 0
C891 Iin.n292 Vss 0.00356f
C892 Iin.n293 Vss 0.00356f
C893 Iin.n294 Vss 0
C894 Iin.n295 Vss 0
C895 Iin.n296 Vss 0
C896 Iin.n297 Vss 0
C897 Iin.n298 Vss 0.00356f
C898 Iin.n299 Vss 0.00318f
C899 Iin.n300 Vss 0
C900 Iin.n301 Vss 0
C901 Iin.n302 Vss 0
C902 Iin.n303 Vss -0
C903 Iin.n304 Vss 0
C904 Iin.n305 Vss 0
C905 Iin.n306 Vss 0
C906 Iin.n307 Vss 0
C907 Iin.n308 Vss 0
C908 Iin.n309 Vss 0
C909 Iin.n310 Vss 0
C910 Iin.n311 Vss 0
C911 Iin.n312 Vss 0
C912 Iin.n313 Vss 0
C913 Iin.n314 Vss 0
C914 Iin.n315 Vss 0
C915 Iin.n316 Vss 0
C916 Iin.n317 Vss 0
C917 Iin.n318 Vss 0
C918 Iin.n319 Vss 0
C919 Iin.n320 Vss 0
C920 Iin.n321 Vss 0
C921 Iin.n322 Vss 0
C922 Iin.n323 Vss 0
C923 Iin.n324 Vss 0
C924 Iin.n325 Vss 0
C925 Iin.n326 Vss 0
C926 Iin.n327 Vss 0.00202f
C927 Iin.n328 Vss 0
C928 Iin.n329 Vss 0.00161f
C929 Iin.n330 Vss 0.00121f
C930 Iin.n331 Vss 0
C931 Iin.n332 Vss 0.00202f
C932 Iin.n333 Vss 0
C933 Iin.n334 Vss 0
C934 Iin.n335 Vss 0
C935 Iin.n336 Vss 0.00189f
C936 Iin.n337 Vss 0
C937 Iin.n338 Vss 0
C938 Iin.n339 Vss 0
C939 Iin.n340 Vss 0
C940 Iin.n341 Vss 0
C941 Iin.n342 Vss 0
C942 Iin.n343 Vss 0
C943 Iin.n344 Vss 0.00116f
C944 Iin.n345 Vss 0
C945 Iin.n346 Vss 0.00116f
C946 Iin.n347 Vss 0
C947 Iin.n348 Vss 0
C948 Iin.n349 Vss 0
C949 Iin.n350 Vss 0
C950 Iin.n351 Vss 0
C951 Iin.n352 Vss 0
C952 Iin.n353 Vss 0
C953 Iin.n354 Vss 0.00202f
C954 Iin.n355 Vss 0
C955 Iin.n356 Vss 0
C956 Iin.n357 Vss 0
C957 Iin.n358 Vss 0
C958 Iin.n359 Vss 0
C959 Iin.n360 Vss 0
C960 Iin.n361 Vss 0
C961 Iin.n362 Vss 0
C962 Iin.n363 Vss 0.0019f
C963 Iin.n364 Vss 0.00128f
C964 Iin.n365 Vss 0
C965 Iin.n366 Vss 0
C966 Iin.n367 Vss 0
C967 Iin.n368 Vss 0
C968 Iin.n369 Vss 0
C969 Iin.n370 Vss 0
C970 Iin.n371 Vss 0
C971 Iin.n372 Vss 0
C972 Iin.n373 Vss 0
C973 Iin.n374 Vss 0.00116f
C974 Iin.n375 Vss 0.00116f
C975 Iin.n376 Vss 0.00116f
C976 Iin.n377 Vss 0
C977 Iin.n378 Vss 0
C978 Iin.n379 Vss 0
C979 Iin.n380 Vss 0
C980 Iin.n381 Vss 0.0011f
C981 Iin.n382 Vss 0
C982 Iin.n383 Vss 0
C983 Iin.n384 Vss 0
C984 Iin.n385 Vss 0
C985 Iin.n386 Vss 0
C986 Iin.n387 Vss 0
C987 Iin.n388 Vss 0
C988 Iin.n389 Vss 0
C989 Iin.n390 Vss 0.00116f
C990 Iin.n391 Vss 0
C991 Iin.n392 Vss 0.00135f
C992 Iin.n393 Vss 0
C993 Iin.n394 Vss 0
C994 Iin.n395 Vss 0
C995 Iin.n396 Vss 0
C996 Iin.n397 Vss 0
C997 Iin.n398 Vss 0
C998 Iin.n399 Vss 0
C999 Iin.n400 Vss 0
C1000 Iin.n401 Vss 0
C1001 Iin.n402 Vss 0
C1002 Iin.n404 Vss 0
C1003 Iin.n405 Vss 0
C1004 Iin.n406 Vss 0
C1005 Iin.n407 Vss 0
C1006 Iin.n408 Vss 0
C1007 Iin.n409 Vss 0
C1008 Iin.n410 Vss 0
C1009 Iin.n411 Vss 0
C1010 Iin.n412 Vss 0
C1011 Iin.n413 Vss 0.00126f
C1012 Iin.n414 Vss 0.00202f
C1013 Iin.n415 Vss 0
C1014 Iin.n416 Vss 0
C1015 Iin.n417 Vss 0
C1016 Iin.n418 Vss 0
C1017 Iin.n419 Vss 0.00125f
C1018 Iin.n420 Vss 0
C1019 Iin.n421 Vss 0
C1020 Iin.n422 Vss 0.00116f
C1021 Iin.n423 Vss 0
C1022 Iin.n424 Vss 0
C1023 Iin.n425 Vss 0
C1024 Iin.n426 Vss 0
C1025 Iin.n427 Vss 0
C1026 Iin.n428 Vss 0
C1027 Iin.n429 Vss 0.00116f
C1028 Iin.n430 Vss 0
C1029 Iin.n431 Vss 0
C1030 Iin.n432 Vss 0
C1031 Iin.n433 Vss 0
C1032 Iin.n434 Vss 0
C1033 Iin.n435 Vss 0.00116f
C1034 Iin.n436 Vss 0
C1035 Iin.n437 Vss 0
C1036 Iin.n438 Vss 0
C1037 Iin.n439 Vss 0
C1038 Iin.n440 Vss 0
C1039 Iin.n441 Vss 0
C1040 Iin.n442 Vss 0
C1041 Iin.n443 Vss 0
C1042 Iin.n444 Vss 0
C1043 Iin.n445 Vss 0.00116f
C1044 Iin.n446 Vss 0.00129f
C1045 Iin.n447 Vss 0
C1046 Iin.n448 Vss 0
C1047 Iin.n449 Vss 0
C1048 Iin.n450 Vss 0
C1049 Iin.n451 Vss 0
C1050 Iin.n452 Vss 0.00139f
C1051 Iin.n453 Vss 0.00116f
C1052 Iin.n454 Vss 0.00199f
C1053 Iin.n455 Vss 0.00119f
C1054 Iin.n456 Vss 0
C1055 Iin.n457 Vss 0
C1056 Iin.n458 Vss 0.00116f
C1057 Iin.n459 Vss 0
C1058 Iin.n460 Vss 0
C1059 Iin.n461 Vss 0
C1060 Iin.n462 Vss 0
C1061 Iin.n463 Vss 0
C1062 Iin.n464 Vss 0
C1063 Iin.n465 Vss 0
C1064 Iin.n466 Vss 0
C1065 Iin.n467 Vss 0
C1066 Iin.n468 Vss 0.00116f
C1067 Iin.n469 Vss 0.00139f
C1068 Iin.n470 Vss 0.00161f
C1069 Iin.n471 Vss 0.00384f
C1070 Iin.n472 Vss 0.00657f
C1071 Iin.n473 Vss 0.01098f
C1072 Iin.n474 Vss 0
C1073 Iin.n475 Vss 0
C1074 Iin.n476 Vss 0
C1075 Iin.n477 Vss 0
C1076 Iin.n478 Vss 0
C1077 Iin.n479 Vss 0
C1078 Iin.n480 Vss 0
C1079 Iin.n481 Vss 0
C1080 Iin.n482 Vss 0
C1081 Iin.n483 Vss 0
C1082 Iin.n484 Vss 0
C1083 Iin.n485 Vss 0
C1084 Iin.n486 Vss 0
C1085 Iin.n487 Vss 0
C1086 Iin.n488 Vss 0
C1087 Iin.n489 Vss 0
C1088 Iin.n490 Vss 0
C1089 Iin.n491 Vss 0
C1090 Iin.n492 Vss 0
C1091 Iin.n493 Vss 0
C1092 Iin.n494 Vss 0
C1093 Iin.n495 Vss 0
C1094 Iin.n496 Vss 0
C1095 Iin.n497 Vss 0
C1096 Iin.n498 Vss 0
C1097 Iin.n499 Vss 0
C1098 Iin.n500 Vss 0
C1099 Iin.n501 Vss 0
C1100 Iin.n502 Vss 0
C1101 Iin.n503 Vss 0
C1102 Iin.n504 Vss 0
C1103 Iin.n505 Vss 0
C1104 Iin.n506 Vss 0
C1105 Iin.n507 Vss 0
C1106 Iin.n508 Vss 0
C1107 Iin.n509 Vss 0
C1108 Iin.n510 Vss 0
C1109 Iin.n511 Vss 0
C1110 Iin.n512 Vss 0
C1111 Iin.n513 Vss 0
C1112 Iin.n514 Vss 0.00121f
C1113 Iin.n515 Vss 0
C1114 Iin.n516 Vss 0.00141f
C1115 Iin.n517 Vss 0
C1116 Iin.n518 Vss 0
C1117 Iin.n519 Vss 0
C1118 Iin.n520 Vss 0.00165f
C1119 Iin.n521 Vss 0.00144f
C1120 Iin.n522 Vss 0.00868f
C1121 Iin.n523 Vss 0.00134f
C1122 Iin.n524 Vss 0.00136f
C1123 Iin.n525 Vss 0
C1124 Iin.n526 Vss 0
C1125 Iin.n527 Vss 0.00136f
C1126 Iin.n528 Vss 0
C1127 Iin.n529 Vss 0
C1128 Iin.n530 Vss 0.00136f
C1129 Iin.n531 Vss 0.00134f
C1130 Iin.n532 Vss 0.00207f
C1131 Iin.n533 Vss 0.00207f
C1132 Iin.n534 Vss 0.00134f
C1133 Iin.n535 Vss 0.00136f
C1134 Iin.n536 Vss 0
C1135 Iin.n537 Vss 0
C1136 Iin.n538 Vss 0.00136f
C1137 Iin.n539 Vss 0
C1138 Iin.n540 Vss 0
C1139 Iin.n541 Vss 0.00136f
C1140 Iin.n542 Vss 0.00134f
C1141 Iin.n543 Vss 0.00207f
C1142 Iin.n544 Vss 0.00207f
C1143 Iin.n545 Vss 0.00134f
C1144 Iin.n546 Vss 0.00136f
C1145 Iin.n547 Vss 0
C1146 Iin.n548 Vss 0.00471f
C1147 Iin.n549 Vss 0
C1148 Iin.n550 Vss 0.00136f
C1149 Iin.n551 Vss 0
C1150 Iin.n552 Vss 0
C1151 Iin.n553 Vss 0.00136f
C1152 Iin.n554 Vss 0.00134f
C1153 Iin.n555 Vss 0.00207f
C1154 Iin.n556 Vss 0.00207f
C1155 Iin.n557 Vss 0.00134f
C1156 Iin.n558 Vss 0.00136f
C1157 Iin.n559 Vss 0
C1158 Iin.n560 Vss 0
C1159 Iin.n561 Vss 0.00136f
C1160 Iin.n562 Vss 0
C1161 Iin.n563 Vss 0
C1162 Iin.n564 Vss 0.00136f
C1163 Iin.n565 Vss 0.00134f
C1164 Iin.n566 Vss 0.00207f
C1165 Iin.n567 Vss 0.00207f
C1166 Iin.n568 Vss 0.00134f
C1167 Iin.n569 Vss 0.00136f
C1168 Iin.n570 Vss 0
C1169 Iin.n571 Vss 0
C1170 Iin.n572 Vss 0.00136f
C1171 Iin.n573 Vss 0
C1172 Iin.n574 Vss 0
C1173 Iin.n575 Vss 0.00136f
C1174 Iin.n576 Vss 0.00134f
C1175 Iin.n577 Vss 0.00207f
C1176 Iin.n578 Vss 0.00207f
C1177 Iin.n579 Vss 0.00134f
C1178 Iin.n580 Vss 0.00136f
C1179 Iin.n581 Vss 0
C1180 Iin.n582 Vss 0
C1181 Iin.n583 Vss 0.00241f
C1182 Iin.n584 Vss 0
C1183 Iin.n585 Vss 0
C1184 Iin.n586 Vss 0
C1185 Iin.n587 Vss 0.00356f
C1186 Iin.n588 Vss 0
C1187 Iin.n589 Vss 0
C1188 Iin.n590 Vss 0
C1189 Iin.n591 Vss 0
C1190 Iin.n592 Vss 0.00399f
C1191 Iin.n593 Vss 0
C1192 Iin.n594 Vss -0
C1193 Iin.n595 Vss 0
C1194 Iin.n596 Vss 0
C1195 Vdd.n0 Vss 0.01959f
C1196 Vdd.n1 Vss 0.01149f
C1197 Vdd.n2 Vss 0.00408f
C1198 Vdd.n3 Vss 0.00657f
C1199 Vdd.n4 Vss 0.00657f
C1200 Vdd.n5 Vss 0.00407f
C1201 Vdd.n6 Vss 0.00161f
C1202 Vdd.n7 Vss 0.00517f
C1203 Vdd.n8 Vss 0.00517f
C1204 Vdd.n9 Vss 0.00161f
C1205 Vdd.n10 Vss 0.00407f
C1206 Vdd.n11 Vss 0.03615f
C1207 Vdd.n12 Vss 0.05226f
C1208 Vdd.n13 Vss 0.03615f
C1209 Vdd.n14 Vss 0.00408f
C1210 Vdd.n15 Vss 0.00318f
C1211 Vdd.n16 Vss 0.07502f
C1212 Vdd.n17 Vss 0.01959f
C1213 Vdd.n18 Vss 0.01149f
C1214 Vdd.n19 Vss 0.00408f
C1215 Vdd.n20 Vss 0.00657f
C1216 Vdd.n21 Vss 0.00657f
C1217 Vdd.n22 Vss 0.00407f
C1218 Vdd.n23 Vss 0.00161f
C1219 Vdd.n24 Vss 0.00517f
C1220 Vdd.n25 Vss 0.00517f
C1221 Vdd.n26 Vss 0.00161f
C1222 Vdd.n27 Vss 0.00407f
C1223 Vdd.n28 Vss 0.03615f
C1224 Vdd.n29 Vss 0.05226f
C1225 Vdd.n30 Vss 0.03615f
C1226 Vdd.n31 Vss 0.00408f
C1227 Vdd.n32 Vss 0.00318f
C1228 Vdd.n33 Vss 0.07502f
C1229 Vdd.n34 Vss 0.01959f
C1230 Vdd.n35 Vss 0.01149f
C1231 Vdd.n36 Vss 0.00408f
C1232 Vdd.n37 Vss 0.00657f
C1233 Vdd.n38 Vss 0.03615f
C1234 Vdd.n39 Vss 0.00407f
C1235 Vdd.n40 Vss 0.00161f
C1236 Vdd.n41 Vss 0.00517f
C1237 Vdd.n42 Vss 0.00517f
C1238 Vdd.n43 Vss 0.00161f
C1239 Vdd.n44 Vss 0.00407f
C1240 Vdd.n45 Vss 0.00657f
C1241 Vdd.n46 Vss 0.05226f
C1242 Vdd.n47 Vss 0.03615f
C1243 Vdd.n48 Vss 0.00408f
C1244 Vdd.n49 Vss 0.00318f
C1245 Vdd.n50 Vss 0.08393f
C1246 Vdd.n51 Vss 0.05841f
C1247 Vdd.n52 Vss 0.0501f
C1248 Vss.n0 Vss 0.00188f
C1249 Vss.n1 Vss 0.0011f
C1250 Vss.n2 Vss 0.00979f
C1251 Vss.n3 Vss 0
C1252 Vss.n4 Vss 0
C1253 Vss.n5 Vss 0.00592f
C1254 Vss.n6 Vss 0
C1255 Vss.n7 Vss 0
C1256 Vss.n8 Vss 0.00341f
C1257 Vss.n9 Vss 0
C1258 Vss.n10 Vss 0
C1259 Vss.n11 Vss 0
C1260 Vss.n12 Vss 0
C1261 Vss.n13 Vss 0
C1262 Vss.n14 Vss 0
C1263 Vss.n15 Vss 0
C1264 Vss.n16 Vss 0
C1265 Vss.n17 Vss 0
C1266 Vss.n18 Vss 0
C1267 Vss.n19 Vss 0
C1268 Vss.n20 Vss 0
C1269 Vss.n21 Vss 0
C1270 Vss.n22 Vss 0.00341f
C1271 Vss.n23 Vss 0
C1272 Vss.n24 Vss 0
C1273 Vss.n25 Vss 0.00474f
C1274 Vss.n26 Vss 0.00474f
C1275 Vss.n27 Vss 0.00935f
C1276 Vss.n28 Vss 0
C1277 Vss.n29 Vss 0.00341f
C1278 Vss.n30 Vss 0
C1279 Vss.n31 Vss 0
C1280 Vss.n32 Vss 0
C1281 Vss.n33 Vss 0
C1282 Vss.n34 Vss 0
C1283 Vss.n35 Vss 0
C1284 Vss.n36 Vss 0
C1285 Vss.n37 Vss 0
C1286 Vss.n38 Vss 0.00558f
C1287 Vss.n39 Vss 0
C1288 Vss.n40 Vss 0
C1289 Vss.n41 Vss 0.00341f
C1290 Vss.n42 Vss 0
C1291 Vss.n43 Vss 0
C1292 Vss.n44 Vss 0
C1293 Vss.n45 Vss 0
C1294 Vss.n46 Vss 0.00188f
C1295 Vss.n47 Vss 0
C1296 Vss.n48 Vss 0
C1297 Vss.n49 Vss 0
C1298 Vss.n50 Vss 0
C1299 Vss.n51 Vss 0
C1300 Vss.n52 Vss 0.0011f
C1301 Vss.n53 Vss 0
C1302 Vss.n54 Vss 0
C1303 Vss.n55 Vss 0
C1304 Vss.n56 Vss 0
C1305 Vss.n57 Vss 0.00592f
C1306 Vss.n58 Vss 0
C1307 Vss.n59 Vss 0
C1308 Vss.n60 Vss 0
C1309 Vss.n61 Vss 0.00368f
C1310 Vss.n62 Vss 0.0019f
C1311 Vss.n63 Vss 0.00188f
C1312 Vss.n64 Vss 0
C1313 Vss.n65 Vss 0
C1314 Vss.n66 Vss 0
C1315 Vss.n67 Vss 0
C1316 Vss.n68 Vss 0
C1317 Vss.n69 Vss 0
C1318 Vss.n70 Vss 0
C1319 Vss.n71 Vss 0
C1320 Vss.n72 Vss 0
C1321 Vss.n73 Vss 0.023f
C1322 Vss.n74 Vss 0.00103f
C1323 Vss.n75 Vss 0.00375f
C1324 Vss.n76 Vss 0.00105f
C1325 Vss.n77 Vss 0
C1326 Vss.n78 Vss 0
C1327 Vss.n79 Vss 0
C1328 Vss.n80 Vss 0
C1329 Vss.n81 Vss 0
C1330 Vss.n82 Vss 0.01046f
C1331 Vss.n83 Vss 0
C1332 Vss.n84 Vss 0
C1333 Vss.n85 Vss 0
C1334 Vss.n86 Vss 0.01046f
C1335 Vss.n87 Vss 0
C1336 Vss.n88 Vss 0.00708f
C1337 Vss.n89 Vss 0.00392f
C1338 Vss.n90 Vss 0.004f
C1339 Vss.n91 Vss 0.004f
C1340 Vss.n92 Vss 0
C1341 Vss.n93 Vss 0
C1342 Vss.n94 Vss 0
C1343 Vss.n95 Vss 0
C1344 Vss.n96 Vss 0
C1345 Vss.n97 Vss 0.01046f
C1346 Vss.n98 Vss 0
C1347 Vss.n99 Vss 0.004f
C1348 Vss.n100 Vss 0.004f
C1349 Vss.n101 Vss 0.004f
C1350 Vss.n102 Vss 0
C1351 Vss.n103 Vss 0
C1352 Vss.n104 Vss 0
C1353 Vss.n105 Vss 0
C1354 Vss.n106 Vss 0
C1355 Vss.n107 Vss 0.01046f
C1356 Vss.n108 Vss 0
C1357 Vss.n109 Vss 0.004f
C1358 Vss.n110 Vss 0.004f
C1359 Vss.n111 Vss 0.004f
C1360 Vss.n112 Vss 0
C1361 Vss.n113 Vss 0
C1362 Vss.n114 Vss 0
C1363 Vss.n115 Vss 0
C1364 Vss.n116 Vss 0
C1365 Vss.n117 Vss 0.01046f
C1366 Vss.n118 Vss 0
C1367 Vss.n119 Vss 0.004f
C1368 Vss.n120 Vss 0.004f
C1369 Vss.n121 Vss 0.004f
C1370 Vss.n122 Vss 0
C1371 Vss.n123 Vss 0
C1372 Vss.n124 Vss 0
C1373 Vss.n125 Vss 0
C1374 Vss.n126 Vss 0
C1375 Vss.n127 Vss 0.01046f
C1376 Vss.n128 Vss 0
C1377 Vss.n129 Vss 0.004f
C1378 Vss.n130 Vss 0.004f
C1379 Vss.n131 Vss 0.004f
C1380 Vss.n132 Vss 0
C1381 Vss.n133 Vss 0
C1382 Vss.n134 Vss 0
C1383 Vss.n135 Vss 0
C1384 Vss.n136 Vss 0
C1385 Vss.n137 Vss 0.01046f
C1386 Vss.n138 Vss 0
C1387 Vss.n139 Vss 0.004f
C1388 Vss.n140 Vss 0.004f
C1389 Vss.n141 Vss 0.004f
C1390 Vss.n142 Vss 0
C1391 Vss.n143 Vss 0
C1392 Vss.n144 Vss 0
C1393 Vss.n145 Vss 0
C1394 Vss.n146 Vss 0
C1395 Vss.n147 Vss 0.01046f
C1396 Vss.n148 Vss 0
C1397 Vss.n149 Vss 0.00792f
C1398 Vss.n150 Vss 0
C1399 Vss.n151 Vss 0
C1400 Vss.n152 Vss 0
C1401 Vss.n153 Vss 0.00355f
C1402 Vss.n154 Vss 0
C1403 Vss.n155 Vss 0
C1404 Vss.n156 Vss 0.00423f
C1405 Vss.n157 Vss 0
C1406 Vss.n158 Vss 0.00392f
C1407 Vss.n159 Vss 0.00392f
C1408 Vss.n160 Vss 0
C1409 Vss.n161 Vss 0.00392f
C1410 Vss.n162 Vss 0.00392f
C1411 Vss.n163 Vss 0.03518f
C1412 Vss.n164 Vss 0
C1413 Vss.n165 Vss 0.00392f
C1414 Vss.n166 Vss 0.00392f
C1415 Vss.n167 Vss 0
C1416 Vss.n168 Vss 0.00392f
C1417 Vss.n169 Vss 0.00392f
C1418 Vss.n170 Vss 0
C1419 Vss.n171 Vss 0
C1420 Vss.n172 Vss 0
C1421 Vss.n173 Vss 0.00392f
C1422 Vss.n174 Vss 0.00392f
C1423 Vss.n175 Vss 0.00606f
C1424 Vss.n176 Vss 0.00606f
C1425 Vss.n177 Vss 0.00392f
C1426 Vss.n178 Vss 0.02546f
C1427 Vss.n179 Vss 0.00392f
C1428 Vss.n180 Vss 0.00606f
C1429 Vss.n181 Vss 0.00606f
C1430 Vss.n182 Vss 0.00606f
C1431 Vss.n183 Vss 0.00392f
C1432 Vss.n184 Vss 0.00606f
C1433 Vss.n185 Vss 0.00392f
C1434 Vss.n186 Vss 0.00606f
C1435 Vss.n187 Vss 0.00606f
C1436 Vss.n188 Vss 0.00606f
C1437 Vss.n189 Vss 0.00392f
C1438 Vss.n190 Vss 0.00606f
C1439 Vss.n191 Vss 0.00392f
C1440 Vss.n192 Vss 0.00606f
C1441 Vss.n193 Vss 0.00606f
C1442 Vss.n194 Vss 0.00606f
C1443 Vss.n195 Vss 0.00392f
C1444 Vss.n196 Vss 0.00606f
C1445 Vss.n197 Vss 0.00392f
C1446 Vss.n198 Vss 0.00606f
C1447 Vss.n199 Vss 0.00606f
C1448 Vss.n200 Vss 0.00606f
C1449 Vss.n201 Vss 0.00392f
C1450 Vss.n202 Vss 0.00606f
C1451 Vss.n203 Vss 0.00392f
C1452 Vss.n204 Vss 0.00606f
C1453 Vss.n205 Vss 0.00606f
C1454 Vss.n206 Vss 0.00392f
C1455 Vss.n207 Vss 0
C1456 Vss.n208 Vss 0
C1457 Vss.n209 Vss 0
C1458 Vss.n210 Vss 0.01046f
C1459 Vss.n211 Vss 0
C1460 Vss.n212 Vss 0
C1461 Vss.n213 Vss 0
C1462 Vss.n214 Vss 0
C1463 Vss.n215 Vss 0
C1464 Vss.n216 Vss 0.01046f
C1465 Vss.n217 Vss 0
C1466 Vss.n218 Vss 0
C1467 Vss.n219 Vss 0
C1468 Vss.n220 Vss 0
C1469 Vss.n221 Vss 0
C1470 Vss.n222 Vss 0.01046f
C1471 Vss.n223 Vss 0
C1472 Vss.n224 Vss 0
C1473 Vss.n225 Vss 0
C1474 Vss.n226 Vss 0
C1475 Vss.n227 Vss 0
C1476 Vss.n228 Vss 0.01046f
C1477 Vss.n229 Vss 0
C1478 Vss.n230 Vss 0
C1479 Vss.n231 Vss 0
C1480 Vss.n232 Vss 0
C1481 Vss.n233 Vss 0
C1482 Vss.n234 Vss 0.01046f
C1483 Vss.n235 Vss 0
C1484 Vss.n236 Vss 0
C1485 Vss.n237 Vss 0
C1486 Vss.n238 Vss 0
C1487 Vss.n239 Vss 0
C1488 Vss.n240 Vss 0.01046f
C1489 Vss.n241 Vss 0
C1490 Vss.n242 Vss 0
C1491 Vss.n243 Vss 0
C1492 Vss.n244 Vss 0
C1493 Vss.n245 Vss 0
C1494 Vss.n246 Vss 0.01046f
C1495 Vss.n247 Vss 0
C1496 Vss.n248 Vss 0
C1497 Vss.n249 Vss 0
C1498 Vss.n250 Vss 0
C1499 Vss.n251 Vss 0
C1500 Vss.n252 Vss 0.01366f
C1501 Vss.n253 Vss 0
C1502 Vss.n254 Vss 0
C1503 Vss.n256 Vss 0.04109f
C1504 Vss.n257 Vss 0.00146f
C1505 Vss.n258 Vss 0
C1506 Vss.n259 Vss 0
C1507 Vss.n260 Vss 0
C1508 Vss.n261 Vss 0
C1509 Vss.n262 Vss 0.01046f
C1510 Vss.n263 Vss 0
C1511 Vss.n264 Vss 0
C1512 Vss.n265 Vss 0
C1513 Vss.n266 Vss 0
C1514 Vss.n267 Vss 0
C1515 Vss.n268 Vss 0
C1516 Vss.n269 Vss 0
C1517 Vss.n270 Vss 0.01046f
C1518 Vss.n271 Vss 0
C1519 Vss.n272 Vss 0
C1520 Vss.n273 Vss 0
C1521 Vss.n274 Vss 0
C1522 Vss.n275 Vss 0
C1523 Vss.n276 Vss 0
C1524 Vss.n277 Vss 0
C1525 Vss.n278 Vss 0.01046f
C1526 Vss.n279 Vss 0
C1527 Vss.n280 Vss 0
C1528 Vss.n281 Vss 0
C1529 Vss.n282 Vss 0
C1530 Vss.n283 Vss 0
C1531 Vss.n284 Vss 0
C1532 Vss.n285 Vss 0
C1533 Vss.n286 Vss 0.01046f
C1534 Vss.n287 Vss 0
C1535 Vss.n288 Vss 0
C1536 Vss.n289 Vss 0
C1537 Vss.n290 Vss 0
C1538 Vss.n291 Vss 0
C1539 Vss.n292 Vss 0
C1540 Vss.n293 Vss 0
C1541 Vss.n294 Vss 0.01046f
C1542 Vss.n295 Vss 0
C1543 Vss.n296 Vss 0
C1544 Vss.n297 Vss 0
C1545 Vss.n298 Vss 0
C1546 Vss.n299 Vss 0
C1547 Vss.n300 Vss 0
C1548 Vss.n301 Vss 0
C1549 Vss.n302 Vss 0.01046f
C1550 Vss.n303 Vss 0
C1551 Vss.n304 Vss 0
C1552 Vss.n305 Vss 0
C1553 Vss.n306 Vss 0
C1554 Vss.n307 Vss 0
C1555 Vss.n308 Vss 0
C1556 Vss.n309 Vss 0
C1557 Vss.n310 Vss 0
C1558 Vss.n311 Vss 0
C1559 Vss.n312 Vss 0
C1560 Vss.n313 Vss 0.01046f
C1561 Vss.n314 Vss 0
C1562 Vss.n315 Vss 0
C1563 Vss.n316 Vss 0
C1564 Vss.n317 Vss 0
C1565 Vss.n318 Vss 0
C1566 Vss.n319 Vss 0
C1567 Vss.n320 Vss 0
C1568 Vss.n321 Vss 0.01046f
C1569 Vss.n322 Vss 0
C1570 Vss.n323 Vss 0
C1571 Vss.n324 Vss 0
C1572 Vss.n325 Vss 0
C1573 Vss.n326 Vss 0.00459f
C1574 Vss.n327 Vss 0
C1575 Vss.n328 Vss 0
C1576 Vss.n329 Vss 0
C1577 Vss.n330 Vss 0
C1578 Vss.n331 Vss 0
C1579 Vss.n332 Vss 0
C1580 Vss.n333 Vss 0
C1581 Vss.n334 Vss 0
C1582 Vss.n335 Vss 0
C1583 Vss.n336 Vss 0.004f
C1584 Vss.n337 Vss 0
C1585 Vss.n338 Vss 0
C1586 Vss.n339 Vss 0
C1587 Vss.n340 Vss 0
C1588 Vss.n341 Vss 0
C1589 Vss.n342 Vss 0
C1590 Vss.n343 Vss 0
C1591 Vss.n344 Vss 0.004f
C1592 Vss.n345 Vss 0
C1593 Vss.n346 Vss 0
C1594 Vss.n347 Vss 0
C1595 Vss.n348 Vss 0
C1596 Vss.n349 Vss 0
C1597 Vss.n350 Vss 0
C1598 Vss.n351 Vss 0
C1599 Vss.n352 Vss 0
C1600 Vss.n353 Vss 0
C1601 Vss.n354 Vss 0.004f
C1602 Vss.n355 Vss 0
C1603 Vss.n356 Vss 0
C1604 Vss.n357 Vss 0.01382f
C1605 Vss.n358 Vss 0
C1606 Vss.n359 Vss 0
C1607 Vss.n360 Vss 0
C1608 Vss.n361 Vss 0
C1609 Vss.n362 Vss 0
C1610 Vss.n363 Vss 0.004f
C1611 Vss.n364 Vss 0
C1612 Vss.n365 Vss 0
C1613 Vss.n366 Vss 0
C1614 Vss.n367 Vss 0
C1615 Vss.n368 Vss 0
C1616 Vss.n369 Vss 0
C1617 Vss.n370 Vss 0
C1618 Vss.n371 Vss 0
C1619 Vss.n372 Vss 0
C1620 Vss.n373 Vss 0.004f
C1621 Vss.n374 Vss 0
C1622 Vss.n375 Vss 0
C1623 Vss.n376 Vss 0
C1624 Vss.n377 Vss 0
C1625 Vss.n378 Vss 0
C1626 Vss.n379 Vss 0
C1627 Vss.n380 Vss 0.00483f
C1628 Vss.n381 Vss 0
C1629 Vss.n382 Vss 0
C1630 Vss.n383 Vss -0
C1631 Vss.n384 Vss 0
C1632 Vss.n385 Vss 0
C1633 Vss.n386 Vss 0
C1634 Vss.n387 Vss 0
C1635 Vss.n388 Vss 0
C1636 Vss.n389 Vss 0
C1637 Vss.n390 Vss 0.00341f
C1638 Vss.n391 Vss 0
C1639 Vss.n392 Vss 0.00324f
C1640 Vss.n393 Vss 0.0019f
C1641 Vss.n394 Vss 0.0011f
C1642 Vss.n395 Vss 0
C1643 Vss.n396 Vss 0
C1644 Vss.n397 Vss 0
C1645 Vss.n398 Vss 0
C1646 Vss.n399 Vss 0
C1647 Vss.n400 Vss 0.00341f
C1648 Vss.n401 Vss 0
C1649 Vss.n402 Vss 0
C1650 Vss.n403 Vss 0
C1651 Vss.n404 Vss 0
C1652 Vss.n405 Vss 0
C1653 Vss.n406 Vss 0
C1654 Vss.n407 Vss 0
C1655 Vss.n408 Vss 0
C1656 Vss.n409 Vss 0
C1657 Vss.n410 Vss 0.00396f
C1658 Vss.n411 Vss 0.00341f
C1659 Vss.n412 Vss 0.00409f
C1660 Vss.n413 Vss 0
C1661 Vss.n414 Vss 0
C1662 Vss.n415 Vss 0
C1663 Vss.n416 Vss 0
C1664 Vss.n417 Vss 0
C1665 Vss.n418 Vss 0
C1666 Vss.n419 Vss 0
C1667 Vss.n420 Vss 0
C1668 Vss.n421 Vss 0
C1669 Vss.n422 Vss 0
C1670 Vss.n423 Vss 0
C1671 Vss.n424 Vss 0
C1672 Vss.n425 Vss 0
C1673 Vss.n426 Vss 0
C1674 Vss.n427 Vss 0
C1675 Vss.n428 Vss 0
C1676 Vss.n429 Vss 0
C1677 Vss.n430 Vss 0.00371f
C1678 Vss.n431 Vss 0.00341f
C1679 Vss.n432 Vss 0.00379f
C1680 Vss.n433 Vss 0
C1681 Vss.n434 Vss 0
C1682 Vss.n435 Vss 0
C1683 Vss.n436 Vss 0
C1684 Vss.n437 Vss 0
C1685 Vss.n438 Vss 0
C1686 Vss.n439 Vss 0.00409f
C1687 Vss.n440 Vss 0
C1688 Vss.n441 Vss 0.00341f
C1689 Vss.n442 Vss 0.00584f
C1690 Vss.n443 Vss 0.00349f
C1691 Vss.n444 Vss 0
C1692 Vss.n445 Vss 0
C1693 Vss.n446 Vss 0
C1694 Vss.n447 Vss 0
C1695 Vss.n448 Vss 0
C1696 Vss.n449 Vss 0
C1697 Vss.n450 Vss 0
C1698 Vss.n451 Vss 0
C1699 Vss.n452 Vss 0.00354f
C1700 Vss.n453 Vss 0
C1701 Vss.n454 Vss 0
C1702 Vss.n455 Vss 0
C1703 Vss.n456 Vss 0
C1704 Vss.n457 Vss 0
C1705 Vss.n458 Vss 0.00592f
C1706 Vss.n459 Vss 0
C1707 Vss.n460 Vss 0
C1708 Vss.n461 Vss 0
C1709 Vss.n462 Vss 0
C1710 Vss.n463 Vss 0
C1711 Vss.n464 Vss 0
C1712 Vss.n465 Vss 0
C1713 Vss.n466 Vss 0
C1714 Vss.n467 Vss 0
C1715 Vss.n468 Vss 0
C1716 Vss.n469 Vss 0
C1717 Vss.n470 Vss 0.00414f
C1718 Vss.n471 Vss 0
C1719 Vss.n472 Vss 0
C1720 Vss.n473 Vss 0
C1721 Vss.n474 Vss 0.01046f
C1722 Vss.n475 Vss 0.01046f
C1723 Vss.n476 Vss 0.01046f
C1724 Vss.n477 Vss 0
C1725 Vss.n478 Vss 0
C1726 Vss.n479 Vss 0
C1727 Vss.n480 Vss 0
C1728 Vss.n481 Vss 0
C1729 Vss.n482 Vss 0.01046f
C1730 Vss.n483 Vss 0.01046f
C1731 Vss.n484 Vss 0.01046f
C1732 Vss.n485 Vss 0
C1733 Vss.n486 Vss 0
C1734 Vss.n487 Vss 0
C1735 Vss.n488 Vss 0
C1736 Vss.n489 Vss 0
C1737 Vss.n490 Vss 0.01046f
C1738 Vss.n491 Vss 0.01046f
C1739 Vss.n492 Vss 0.01046f
C1740 Vss.n493 Vss 0
C1741 Vss.n494 Vss 0
C1742 Vss.n495 Vss 0
C1743 Vss.n496 Vss 0
C1744 Vss.n497 Vss 0
C1745 Vss.n498 Vss 0.01046f
C1746 Vss.n499 Vss 0.01046f
C1747 Vss.n500 Vss 0.01046f
C1748 Vss.n501 Vss 0
C1749 Vss.n502 Vss 0
C1750 Vss.n503 Vss 0
C1751 Vss.n504 Vss 0
C1752 Vss.n505 Vss 0
C1753 Vss.n506 Vss 0.01046f
C1754 Vss.n507 Vss 0.01046f
C1755 Vss.n508 Vss 0.01046f
C1756 Vss.n509 Vss 0
C1757 Vss.n510 Vss 0
C1758 Vss.n511 Vss 0
C1759 Vss.n512 Vss 0
C1760 Vss.n513 Vss 0
C1761 Vss.n514 Vss 0.01046f
C1762 Vss.n515 Vss 0.01046f
C1763 Vss.n516 Vss 0.01046f
C1764 Vss.n517 Vss 0
C1765 Vss.n518 Vss 0
C1766 Vss.n519 Vss 0
C1767 Vss.n520 Vss 0
C1768 Vss.n521 Vss 0
C1769 Vss.n522 Vss 0.01046f
C1770 Vss.n523 Vss 0.01046f
C1771 Vss.n524 Vss 0.01046f
C1772 Vss.n525 Vss 0
C1773 Vss.n526 Vss 0
C1774 Vss.n527 Vss 0.0011f
C1775 Vss.n528 Vss 0.0117f
C1776 Vss.n529 Vss 0
C1777 Vss.n530 Vss -0
C1778 Vss.n531 Vss 0
C1779 Vss.n532 Vss 0.00162f
C1780 Vss.n533 Vss 0.00186f
C1781 Vss.n534 Vss 0.00266f
C1782 Vss.n535 Vss 0.00257f
C1783 Vss.n536 Vss 0
C1784 Vss.n537 Vss 0
C1785 Vss.n538 Vss 0
C1786 Vss.n539 Vss 0
C1787 Vss.n540 Vss 0
C1788 Vss.n541 Vss 0.00341f
C1789 Vss.n542 Vss 0.00341f
C1790 Vss.n543 Vss 0
C1791 Vss.n544 Vss 0
C1792 Vss.n545 Vss 0
C1793 Vss.n546 Vss 0.0019f
C1794 Vss.n547 Vss 0.00111f
C1795 Vss.n548 Vss 0.00111f
C1796 Vss.n549 Vss 0.0019f
C1797 Vss.n550 Vss 0
C1798 Vss.n551 Vss 0
C1799 Vss.n552 Vss 0
C1800 Vss.n553 Vss 0
C1801 Vss.n554 Vss 0.0019f
C1802 Vss.n555 Vss 0.00111f
C1803 Vss.n556 Vss 0.00111f
C1804 Vss.n557 Vss 0.0019f
C1805 Vss.n558 Vss 0
C1806 Vss.n559 Vss 0
C1807 Vss.n560 Vss 0
C1808 Vss.n561 Vss 0
C1809 Vss.n562 Vss 0.00341f
C1810 Vss.n563 Vss 0.00375f
C1811 Vss.n564 Vss 0
C1812 Vss.n565 Vss 0
C1813 Vss.n566 Vss 0
C1814 Vss.n567 Vss 0
C1815 Vss.n568 Vss 0
C1816 Vss.n569 Vss 0.00196f
C1817 Vss.n570 Vss 0.00958f
C1818 Vss.n571 Vss 0.01128f
C1819 Vss.n572 Vss 0.01928f
C1820 Vss.n573 Vss 0.03222f
C1821 Vss.n574 Vss 0.00592f
C1822 Vss.n575 Vss 0
C1823 Vss.n576 Vss 0
C1824 Vss.n577 Vss 0
C1825 Vss.n578 Vss 0
C1826 Vss.n579 Vss 0
C1827 Vss.n580 Vss 0
C1828 Vss.n581 Vss 0
C1829 Vss.n582 Vss 0
C1830 Vss.n583 Vss 0
C1831 Vss.n584 Vss 0
C1832 Vss.n585 Vss 0
C1833 Vss.n586 Vss 0
C1834 Vss.n587 Vss 0
C1835 Vss.n589 Vss 0
C1836 Vss.n590 Vss 0
C1837 Vss.n591 Vss 0.00341f
C1838 Vss.n592 Vss 0.00341f
C1839 Vss.n593 Vss 0
C1840 Vss.n594 Vss 0
C1841 Vss.n595 Vss 0.00555f
C1842 Vss.n596 Vss 0.00245f
C1843 Unnamed_2af03fd8_2/a_64_n131# Vss -0.48952f
C1844 Vdd Vss -6.12365f
C1845 spike Vss 1.10588f
C1846 Unnamed_2af03fd8_2/a_n64_n339# Vss -0.2714f
.ends
