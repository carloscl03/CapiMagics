** sch_path: /foss/designs/libs/snn_analog/lif/sch/neurona_lvs.sch
.subckt neurona_lvs Iin vdd vss spike spike_neg
*.PININFO vdd:B vss:B Iin:I spike:O spike_neg:O
M1 spike_neg Iin vdd vdd pfet_03v3 L=0.28u W=0.5u nf=1
M2 spike_neg Iin vss vss nfet_03v3 L=0.28u W=0.5u nf=1
M3 spike_reset spike_neg vdd vdd pfet_03v3 L=0.28u W=0.5u nf=1
M4 spike_reset spike_neg vss vss nfet_03v3 L=0.28u W=0.5u nf=1
M7 spike spike_neg vdd vdd pfet_03v3 L=0.28u W=0.5u nf=1
M8 spike spike_neg vss vss nfet_03v3 L=0.28u W=0.5u nf=1
M5 Iin spike_reset vss vss nfet_03v3 L=50u W=2.3u nf=1
XC2 Iin vss cap_mim_2f0fF c_width=28u c_length=5u m=1
.ends
