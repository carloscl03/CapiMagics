* NGSPICE file created from current_mirror.ext - technology: gf180mcuD

.subckt M3 a_n170_n881# a_50_n881# w_n436_n1309# a_n50_n1089# VSUBS
X0 a_50_n881# a_n50_n1089# a_n170_n881# w_n436_n1309# pfet_03v3 ad=4.8p pd=17.2u as=4.8p ps=17.2u w=8u l=0.5u
C0 a_50_n881# a_n170_n881# 1.38159f
C1 a_n170_n881# w_n436_n1309# 0.85443f
C2 a_50_n881# a_n50_n1089# 0.1511f
C3 w_n436_n1309# a_n50_n1089# 0.40291f
C4 a_50_n881# w_n436_n1309# 1.11309f
C5 a_n170_n881# a_n50_n1089# 0.1643f
C6 a_50_n881# VSUBS 0.22915f
C7 a_n170_n881# VSUBS 0.23296f
C8 a_n50_n1089# VSUBS 0.05695f
C9 w_n436_n1309# VSUBS 8.14076f
.ends

.subckt M1 a_n50_n689# a_n388_n853# a_28_n481# a_n178_n481#
X0 a_28_n481# a_n50_n689# a_n178_n481# a_n388_n853# nfet_03v3 ad=3p pd=9.5u as=3p ps=9.5u w=4u l=0.28u
C0 a_28_n481# a_n50_n689# 0.04852f
C1 a_n50_n689# a_n178_n481# 0.05931f
C2 a_28_n481# a_n178_n481# 0.79223f
C3 a_28_n481# a_n388_n853# 0.91438f
C4 a_n178_n481# a_n388_n853# 0.65403f
C5 a_n50_n689# a_n388_n853# 0.43511f
.ends

.subckt M4 a_n170_n241# a_50_n241# w_n436_n669# a_n50_n449# VSUBS
X0 a_50_n241# a_n50_n449# a_n170_n241# w_n436_n669# pfet_03v3 ad=0.96p pd=4.4u as=0.96p ps=4.4u w=1.6u l=0.5u
C0 a_50_n241# a_n170_n241# 0.49483f
C1 a_n170_n241# w_n436_n669# 0.31605f
C2 a_50_n241# a_n50_n449# 0.03432f
C3 w_n436_n669# a_n50_n449# 0.40991f
C4 a_50_n241# w_n436_n669# 0.57366f
C5 a_n170_n241# a_n50_n449# 0.0504f
C6 a_50_n241# VSUBS 0.07004f
C7 a_n170_n241# VSUBS 0.06917f
C8 a_n50_n449# VSUBS 0.05013f
C9 w_n436_n669# VSUBS 4.31562f
.ends

.subckt M2 a_n400_n689# a_n520_n481# a_400_n481# a_n730_n853#
X0 a_400_n481# a_n400_n689# a_n520_n481# a_n730_n853# nfet_03v3 ad=2.4p pd=9.2u as=2.4p ps=9.2u w=4u l=4u
C0 a_400_n481# a_n400_n689# 0.25939f
C1 a_n400_n689# a_n520_n481# 0.38556f
C2 a_400_n481# a_n520_n481# 0.60052f
C3 a_400_n481# a_n730_n853# 1.23378f
C4 a_n520_n481# a_n730_n853# 0.71367f
C5 a_n400_n689# a_n730_n853# 1.90584f
.ends

.subckt current_mirror Avdd Avss A B
XM3_0 Avdd B Avdd B Avss M3
XM1_0 A Avss A Avss M1
XM4_0 Avdd A Avdd A Avss M4
XM2_0 A Avss B Avss M2
R0 B.n2 B.n1 87.6185
R1 B.n2 B.n0 13.0311
R2 B B.n2 9.6755
R3 A.n6 A.n4 88.4721
R4 A.n3 A.n2 40.6645
R5 A.n8 A.n0 15.5896
R6 A.n3 A.n1 14.5508
R7 A.n6 A.n5 11.8027
R8 A.n8 A.n7 9.9545
R9 A.n7 A.n3 0.9455
R10 A.n7 A.n6 0.4775
R11 A A.n8 0.0905
R12 Avss.n43 Avss.n42 22716.8
R13 Avss.n33 Avss.n7 551.184
R14 Avss.n66 Avss.n7 364.974
R15 Avss.n33 Avss.n22 337.663
R16 Avss.n43 Avss.n19 288.007
R17 Avss.n50 Avss.n19 198.625
R18 Avss.n50 Avss.n13 198.625
R19 Avss.n58 Avss.n13 198.625
R20 Avss.n58 Avss.n6 198.625
R21 Avss.n66 Avss.n6 198.625
R22 Avss.n42 Avss.n22 191.177
R23 Avss.n44 Avss.n20 104.514
R24 Avss.n44 Avss.n18 104.514
R25 Avss.n65 Avss.n5 104.514
R26 Avss.n67 Avss.n5 104.514
R27 Avss.n34 Avss.n24 102.376
R28 Avss.n40 Avss.n25 102.376
R29 Avss.n34 Avss.n32 102.376
R30 Avss.n25 Avss.n23 77.6615
R31 Avss.n44 Avss.n43 77.3391
R32 Avss.n40 Avss.n24 15.5561
R33 Avss.n32 Avss.n28 15.5561
R34 Avss.n49 Avss.n20 15.5561
R35 Avss.n49 Avss.n12 15.5561
R36 Avss.n59 Avss.n12 15.5561
R37 Avss.n59 Avss.n8 15.5561
R38 Avss.n65 Avss.n8 15.5561
R39 Avss.n51 Avss.n18 15.5561
R40 Avss.n51 Avss.n14 15.5561
R41 Avss.n57 Avss.n14 15.5561
R42 Avss.n57 Avss.n4 15.5561
R43 Avss.n67 Avss.n4 15.5561
R44 Avss.n42 Avss.n41 7.44893
R45 Avss.n45 Avss.n16 5.55683
R46 Avss.n63 Avss.n1 5.55683
R47 Avss.n46 Avss.n45 5.549
R48 Avss.n38 Avss.n37 5.53703
R49 Avss.n35 Avss.n27 5.53703
R50 Avss.n36 Avss.n35 5.5292
R51 Avss.n71 Avss.n0 5.39275
R52 Avss.n30 Avss.n28 5.2005
R53 Avss.n32 Avss.n31 5.2005
R54 Avss.n32 Avss.n22 5.2005
R55 Avss.n26 Avss.n24 5.2005
R56 Avss.n24 Avss.n22 5.2005
R57 Avss.n40 Avss.n39 5.2005
R58 Avss.n41 Avss.n40 5.2005
R59 Avss.n65 Avss.n64 5.2005
R60 Avss.n66 Avss.n65 5.2005
R61 Avss.n9 Avss.n8 5.2005
R62 Avss.n8 Avss.n6 5.2005
R63 Avss.n60 Avss.n59 5.2005
R64 Avss.n59 Avss.n58 5.2005
R65 Avss.n12 Avss.n11 5.2005
R66 Avss.n13 Avss.n12 5.2005
R67 Avss.n49 Avss.n48 5.2005
R68 Avss.n50 Avss.n49 5.2005
R69 Avss.n21 Avss.n20 5.2005
R70 Avss.n20 Avss.n19 5.2005
R71 Avss.n68 Avss.n67 5.2005
R72 Avss.n67 Avss.n66 5.2005
R73 Avss.n4 Avss.n3 5.2005
R74 Avss.n6 Avss.n4 5.2005
R75 Avss.n57 Avss.n56 5.2005
R76 Avss.n58 Avss.n57 5.2005
R77 Avss.n15 Avss.n14 5.2005
R78 Avss.n14 Avss.n13 5.2005
R79 Avss.n52 Avss.n51 5.2005
R80 Avss.n51 Avss.n50 5.2005
R81 Avss.n18 Avss.n17 5.2005
R82 Avss.n19 Avss.n18 5.2005
R83 Avss.n71 Avss.n70 4.87615
R84 Avss.n70 Avss.n69 4.7615
R85 Avss.n29 Avss.n0 4.7417
R86 Avss Avss.n71 4.5527
R87 Avss.n36 Avss.n26 4.5005
R88 Avss.n39 Avss.n38 4.5005
R89 Avss.n30 Avss.n29 4.5005
R90 Avss.n31 Avss.n27 4.5005
R91 Avss.n53 Avss.n52 4.5005
R92 Avss.n54 Avss.n15 4.5005
R93 Avss.n56 Avss.n55 4.5005
R94 Avss.n3 Avss.n2 4.5005
R95 Avss.n69 Avss.n68 4.5005
R96 Avss.n17 Avss.n16 4.5005
R97 Avss.n48 Avss.n47 4.5005
R98 Avss.n11 Avss.n10 4.5005
R99 Avss.n61 Avss.n60 4.5005
R100 Avss.n62 Avss.n9 4.5005
R101 Avss.n64 Avss.n63 4.5005
R102 Avss.n46 Avss.n21 4.5005
R103 Avss.n41 Avss.n23 3.94566
R104 Avss.n28 Avss.n23 1.19566
R105 Avss.n37 Avss.n0 0.795826
R106 Avss.n70 Avss.n1 0.795826
R107 Avss.n35 Avss.n34 0.371929
R108 Avss.n34 Avss.n33 0.371929
R109 Avss.n37 Avss.n25 0.371929
R110 Avss.n45 Avss.n44 0.371929
R111 Avss.n5 Avss.n1 0.371929
R112 Avss.n7 Avss.n5 0.371929
R113 Avss.n31 Avss.n30 0.1445
R114 Avss.n39 Avss.n26 0.1445
R115 Avss.n38 Avss.n36 0.1445
R116 Avss.n29 Avss.n27 0.1445
R117 Avss.n48 Avss.n21 0.1445
R118 Avss.n48 Avss.n11 0.1445
R119 Avss.n60 Avss.n11 0.1445
R120 Avss.n60 Avss.n9 0.1445
R121 Avss.n64 Avss.n9 0.1445
R122 Avss.n52 Avss.n17 0.1445
R123 Avss.n52 Avss.n15 0.1445
R124 Avss.n56 Avss.n15 0.1445
R125 Avss.n56 Avss.n3 0.1445
R126 Avss.n68 Avss.n3 0.1445
R127 Avss.n53 Avss.n16 0.1445
R128 Avss.n54 Avss.n53 0.1445
R129 Avss.n55 Avss.n54 0.1445
R130 Avss.n55 Avss.n2 0.1445
R131 Avss.n69 Avss.n2 0.1445
R132 Avss.n47 Avss.n46 0.1445
R133 Avss.n47 Avss.n10 0.1445
R134 Avss.n61 Avss.n10 0.1445
R135 Avss.n62 Avss.n61 0.1445
R136 Avss.n63 Avss.n62 0.1445
R137 Avdd.n34 Avdd.n23 1397.13
R138 Avdd.n34 Avdd.n33 1397.13
R139 Avdd.n15 Avdd.n4 663.191
R140 Avdd.n7 Avdd.n4 663.191
R141 Avdd.n36 Avdd.n35 126.439
R142 Avdd.n35 Avdd.n24 126.439
R143 Avdd.n32 Avdd.n26 126.439
R144 Avdd.n26 Avdd.n25 126.439
R145 Avdd.n16 Avdd.n3 70.438
R146 Avdd.n8 Avdd.n3 70.438
R147 Avdd.n13 Avdd.n5 70.438
R148 Avdd.n14 Avdd.n13 70.438
R149 Avdd.n9 Avdd.n8 6.3005
R150 Avdd.n10 Avdd.n5 6.3005
R151 Avdd.n17 Avdd.n16 6.3005
R152 Avdd.n14 Avdd.n2 6.3005
R153 Avdd.n27 Avdd.n24 6.3005
R154 Avdd.n32 Avdd.n31 6.3005
R155 Avdd.n25 Avdd.n22 6.3005
R156 Avdd.n37 Avdd.n36 6.3005
R157 Avdd.n40 Avdd.n19 6.20729
R158 Avdd.n30 Avdd.n28 5.92113
R159 Avdd.n29 Avdd.n20 5.92113
R160 Avdd.n28 Avdd.n21 5.9133
R161 Avdd.n12 Avdd.n11 5.29504
R162 Avdd.n6 Avdd.n0 5.29504
R163 Avdd.n12 Avdd.n1 5.28722
R164 Avdd.n40 Avdd.n39 5.0718
R165 Avdd.n19 Avdd.n18 4.7345
R166 Avdd.n39 Avdd.n38 4.7345
R167 Avdd Avdd.n40 4.5563
R168 Avdd.n18 Avdd.n17 4.5005
R169 Avdd.n2 Avdd.n1 4.5005
R170 Avdd.n9 Avdd.n6 4.5005
R171 Avdd.n11 Avdd.n10 4.5005
R172 Avdd.n22 Avdd.n21 4.5005
R173 Avdd.n38 Avdd.n37 4.5005
R174 Avdd.n29 Avdd.n27 4.5005
R175 Avdd.n31 Avdd.n30 4.5005
R176 Avdd.n7 Avdd.n5 3.31679
R177 Avdd.n8 Avdd.n7 3.31679
R178 Avdd.n15 Avdd.n14 3.31679
R179 Avdd.n16 Avdd.n15 3.31679
R180 Avdd.n33 Avdd.n32 3.31679
R181 Avdd.n33 Avdd.n24 3.31679
R182 Avdd.n36 Avdd.n23 3.31679
R183 Avdd.n25 Avdd.n23 3.31679
R184 Avdd.n39 Avdd.n20 1.18713
R185 Avdd.n13 Avdd.n12 0.7005
R186 Avdd.n13 Avdd.n4 0.7005
R187 Avdd.n3 Avdd.n0 0.7005
R188 Avdd.n4 Avdd.n3 0.7005
R189 Avdd.n19 Avdd.n0 0.561043
R190 Avdd.n28 Avdd.n26 0.274413
R191 Avdd.n34 Avdd.n26 0.274413
R192 Avdd.n35 Avdd.n20 0.274413
R193 Avdd.n35 Avdd.n34 0.274413
R194 Avdd.n10 Avdd.n9 0.1445
R195 Avdd.n17 Avdd.n2 0.1445
R196 Avdd.n18 Avdd.n1 0.1445
R197 Avdd.n11 Avdd.n6 0.1445
R198 Avdd.n31 Avdd.n27 0.1445
R199 Avdd.n37 Avdd.n22 0.1445
R200 Avdd.n38 Avdd.n21 0.1445
R201 Avdd.n30 Avdd.n29 0.1445
C0 Avdd A 0.64053f
C1 B A 0.20092f
C2 Avdd B 0.80348f
C3 Avdd.n0 Avss 0.01507f
C4 Avdd.n1 Avss 0.00773f
C5 Avdd.n2 Avss 0.00238f
C6 Avdd.n3 Avss 0.01093f
C7 Avdd.n4 Avss 0.09246f
C8 Avdd.n5 Avss 0.00668f
C9 Avdd.n6 Avss 0.00762f
C10 Avdd.n7 Avss 0.06065f
C11 Avdd.n8 Avss 0.00668f
C12 Avdd.n9 Avss 0.00238f
C13 Avdd.n10 Avss 0.00238f
C14 Avdd.n11 Avss 0.00762f
C15 Avdd.n12 Avss 0.02314f
C16 Avdd.n13 Avss 0.01093f
C17 Avdd.n14 Avss 0.00668f
C18 Avdd.n15 Avss 0.06065f
C19 Avdd.n16 Avss 0.00668f
C20 Avdd.n17 Avss 0.00238f
C21 Avdd.n18 Avss 0.00698f
C22 Avdd.n19 Avss 0.02798f
C23 Avdd.n20 Avss 0.0296f
C24 Avdd.n21 Avss 0.01408f
C25 Avdd.n22 Avss 0.00238f
C26 Avdd.n23 Avss 0.1118f
C27 Avdd.n24 Avss 0.01097f
C28 Avdd.n25 Avss 0.01097f
C29 Avdd.n26 Avss 0.01924f
C30 Avdd.n27 Avss 0.00238f
C31 Avdd.n28 Avss 0.0672f
C32 Avdd.n29 Avss 0.00928f
C33 Avdd.n30 Avss 0.00928f
C34 Avdd.n31 Avss 0.00238f
C35 Avdd.n32 Avss 0.01097f
C36 Avdd.n33 Avss 0.1118f
C37 Avdd.n34 Avss 0.19467f
C38 Avdd.n35 Avss 0.01924f
C39 Avdd.n36 Avss 0.01097f
C40 Avdd.n37 Avss 0.00238f
C41 Avdd.n38 Avss 0.00698f
C42 Avdd.n39 Avss 0.02089f
C43 Avdd.n40 Avss 0.12782f
C44 Avss.n0 Avss 0.00782f
C45 Avss.n1 Avss 0.00883f
C46 Avss.n2 Avss 0.00125f
C47 Avss.n3 Avss 0.00125f
C48 Avss.n4 Avss 0
C49 Avss.n5 Avss 0.00617f
C50 Avss.n6 Avss 0.03281f
C51 Avss.n7 Avss 0.07567f
C52 Avss.n8 Avss 0
C53 Avss.n9 Avss 0.00125f
C54 Avss.n10 Avss 0.00125f
C55 Avss.n11 Avss 0.00125f
C56 Avss.n12 Avss 0
C57 Avss.n13 Avss 0.03281f
C58 Avss.n14 Avss 0
C59 Avss.n15 Avss 0.00125f
C60 Avss.n16 Avss 0.0037f
C61 Avss.n17 Avss 0.00102f
C62 Avss.n18 Avss 0.00363f
C63 Avss.n19 Avss 0.04019f
C64 Avss.n20 Avss 0.00363f
C65 Avss.n21 Avss 0.00102f
C66 Avss.n22 Avss 0.04368f
C67 Avss.n24 Avss 0.00357f
C68 Avss.n25 Avss 0.13468f
C69 Avss.n26 Avss 0.00102f
C70 Avss.n27 Avss 0.00354f
C71 Avss.n28 Avss 0.00357f
C72 Avss.n29 Avss 0.00304f
C73 Avss.n30 Avss 0.00102f
C74 Avss.n31 Avss 0.00102f
C75 Avss.n32 Avss 0.00357f
C76 Avss.n33 Avss 0.07341f
C77 Avss.n34 Avss 0.00604f
C78 Avss.n35 Avss 0.0186f
C79 Avss.n36 Avss 0.00416f
C80 Avss.n37 Avss 0.00882f
C81 Avss.n38 Avss 0.00354f
C82 Avss.n39 Avss 0.00102f
C83 Avss.n40 Avss 0.00357f
C84 Avss.n41 Avss 0.02865f
C85 Avss.n42 Avss 0.31848f
C86 Avss.n43 Avss 0.34564f
C87 Avss.n44 Avss 0.11291f
C88 Avss.n45 Avss 0.02526f
C89 Avss.n46 Avss 0.00493f
C90 Avss.n47 Avss 0.00125f
C91 Avss.n48 Avss 0.00125f
C92 Avss.n49 Avss 0
C93 Avss.n50 Avss 0.03281f
C94 Avss.n51 Avss 0
C95 Avss.n52 Avss 0.00125f
C96 Avss.n53 Avss 0.00125f
C97 Avss.n54 Avss 0.00125f
C98 Avss.n55 Avss 0.00125f
C99 Avss.n56 Avss 0.00125f
C100 Avss.n57 Avss 0
C101 Avss.n58 Avss 0.03281f
C102 Avss.n59 Avss 0
C103 Avss.n60 Avss 0.00125f
C104 Avss.n61 Avss 0.00125f
C105 Avss.n62 Avss 0.00125f
C106 Avss.n63 Avss 0.0037f
C107 Avss.n64 Avss 0.00102f
C108 Avss.n65 Avss 0.00363f
C109 Avss.n66 Avss 0.04655f
C110 Avss.n67 Avss 0.00363f
C111 Avss.n68 Avss 0.00102f
C112 Avss.n69 Avss 0.00321f
C113 Avss.n70 Avss 0.00621f
C114 Avss.n71 Avss 0.05348f
C115 A.n0 Avss 0.56246f
C116 A.n1 Avss 0.05438f
C117 A.n2 Avss 0.03362f
C118 A.n3 Avss 0.1915f
C119 A.n4 Avss 0.03394f
C120 A.n5 Avss 0.2157f
C121 A.n6 Avss 0.23333f
C122 A.n7 Avss 0.10153f
C123 A.n8 Avss 0.32301f
C124 B.n0 Avss 0.4083f
C125 B.n1 Avss 0.10068f
C126 B.n2 Avss 0.45165f
C127 B Avss -0.89201f
C128 A Avss -1.6006f
C129 Avdd Avss -2.52233f
.ends
