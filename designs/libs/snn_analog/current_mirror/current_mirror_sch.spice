** sch_path: /foss/designs/CapiMagics/sch/current_mirror/current_mirror.sch
.subckt current_mirror Avdd Avss B A
*.PININFO Avdd:B Avss:B B:B A:B
M1 A A Avss Avss nfet_03v3 L=0.28u W=4u nf=1
M2 B A Avss Avss nfet_03v3 L=4u W=4u nf=1
M3 B B Avdd Avdd pfet_03v3 L=0.5u W=8u nf=1
M4 A A Avdd Avdd pfet_03v3 L=0.5u W=1.6u nf=1
.ends
