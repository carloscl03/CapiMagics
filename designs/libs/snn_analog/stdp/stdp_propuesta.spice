* stdp -- version PROPUESTA, con tres correcciones respecto de stdp_sch.spice
*
* 1. n3 y n4 son EL MISMO NODO. Sin esto n3 queda flotante sin camino de
*    continua, M7 cortado, n4 a tierra y la potenciacion no conduce (Ipot pasa
*    de 0.003 a 224 nA al unirlos). El LVS no lo ve: esquematico y extraido
*    llevan el mismo circuito incompleto.
*
* 2. LECTURA DEL PESO con el signo correcto. El paper (linea 162) dice que la
*    potenciacion INCREMENTA VW, y la celda lo cumple (+146.76 mV medido). Pero
*    `M5 iout vw avdd avdd pfet` tiene transconductancia negativa: vw arriba ->
*    menos Iout. Y en la neurona `Iin` ES la membrana, asi que menos corriente =
*    dispara menos. O sea que potenciar DEBILITABA la sinapsis.
*    Un pfet no puede arreglarlo (el signo es estructural) y un nfet solo drena,
*    cuando la membrana necesita que le inyecten. De ahi transconductor+espejo:
*                    Imax    rango   linealidad   area      signo
*      M5 (hoy)     2.350    1.90      8.3 %     7.50 um2   INVERTIDO
*      Mn+Mp1+Mp2   0.252    1.90      4.8       9.03       correcto
*
*    El espejo se dimensiona por la CADENA, no por la celda: `ifwd` recoge
*    CUATRO sinapsis en paralelo, y ninguna geometria del LIF acepta mas de
*    2758 nA (su maximo, con W=3.5 L=50), y ESE maximo esta justo en la
*    frontera medida de W_M5: disenar ahi es fragil. Con 1009 nA totales la
*    neurona de capa 2 sale W=3.09 L=20 -- area 61.8 um2, comparable a la de
*    capa 1 (62.5) y con 12 pct de margen a W_MAX.
*    La primera version daba 2231 nA POR SINAPSIS: 8924 con las cuatro,
*    factor 9.8 de exceso. El tercio superior del rango de peso no habria
*    hecho nada, y nadie lo habria visto porque el acoplo cruza dos bloques.
*
* 3. M4 y M1 dimensionados por la CONDICION DE EQUILIBRIO del STDP aditivo.
*    Con pre/post no correlacionados la deriva va como r^2*(A+ tau+ - A- tau-);
*    si no es cero los pesos se van al rail. Con tau+ = tau- queda A+ = A-.
*    Cruzando eso con que el suelo de potenciacion se anula en W1 = 0.357
*    (independiente de L), la solucion es UNICA:
*      W4 = 0.30  L4 = 0.28   ->  A- = 223 mV
*      W1 = 0.357 L1 = 0.40   ->  A+ = 222 mV, suelo nulo
*    L1 = 2.00 queda descartada: ninguna W alcanza a equilibrar.
*
* Caracterizacion completa en sch/stdp/results/stdp_knowledge_base.md
** sch_path: /foss/designs/CapiMagics/sch/stdp/stdp_lvs.sch
.subckt stdp avdd avss nvpre nvpost vpre vpost vb_itd vb_idep vb_itp vb_pot vw iout
*.PININFO avss:B avdd:B nvpost:B nvpre:B vpost:B vpre:B vb_idep:B vb_itd:B vb_itp:B vb_pot:B vw:B iout:O
M1 n1 vpot avdd avdd pfet_03v3 L=0.4u W=0.357u nf=1
M2 vw nvpost n1 avdd pfet_03v3 L=0.63u W=0.5u nf=1
M3 vw vpre n2 avss nfet_03v3 L=0.63u W=0.5u nf=1
M4 n2 vdep avss avss nfet_03v3 L=0.28u W=0.3u nf=1
M7 n4 n4 avdd avdd pfet_03v3 L=0.63u W=0.5u nf=1
M8 n4 nvpre vpot avdd pfet_03v3 L=0.63u W=0.5u nf=1
M9 n5 n5 avss avss nfet_03v3 L=0.63u W=0.5u nf=1
M12 n5 vpost vdep avss nfet_03v3 L=0.63u W=0.5u nf=1
M17 vpot vb_itp avdd avdd pfet_03v3 L=4.6u W=0.5u nf=1
MCM_1 n4 vb_pot avss avss nfet_03v3 L=2.8u W=0.61u nf=1
M16 n5 vb_idep avdd avdd pfet_03v3 L=2.8u W=10.2u nf=1
MCM_5 vdep vb_itd n6 avss nfet_03v3 L=10u W=0.5u nf=1
MCM_6 n6 vb_itd n7 avss nfet_03v3 L=10u W=0.5u nf=1
MCM_7 n7 vb_itd n8 avss nfet_03v3 L=10u W=0.5u nf=1
MCM_8 n8 vb_itd n9 avss nfet_03v3 L=10u W=0.5u nf=1
MCM_9 n9 vb_itd avss avss nfet_03v3 L=10u W=0.5u nf=1
x1[0] vdep avss unitcap
x1[1] vdep avss unitcap
x2[0] vw avss unitcap
x2[1] vw avss unitcap
x2[2] vw avss unitcap
x2[3] vw avss unitcap
x2[4] vw avss unitcap
x2[5] vw avss unitcap
x2[6] vw avss unitcap
x2[7] vw avss unitcap
x2[8] vw avss unitcap
x2[9] vw avss unitcap
x3[0] avdd vpot unitcap
x3[1] avdd vpot unitcap
Mn  nd   vw avss avss nfet_03v3 L=6.0u W=0.22u nf=1
Mp1 nd   nd avdd avdd pfet_03v3 L=2.0u W=0.5u nf=1
Mp2 iout nd avdd avdd pfet_03v3 L=30.5u W=0.22u nf=1
.ends

* expanding   symbol:  stdp/unitcap.sym # of pins=2
** sym_path: /foss/designs/CapiMagics/sch/stdp/unitcap.sym
** sch_path: /foss/designs/CapiMagics/sch/stdp/unitcap.sch
.subckt unitcap tp bp
*.PININFO tp:B bp:B
XCdep tp bp cap_mim_2f0fF c_width=5e-6 c_length=5e-6
.ends
