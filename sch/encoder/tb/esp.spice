* espejo de salida: ratio Iout/Iref frente a geometria, corriente y carga
.include /foss/pdks/gf180mcuD/libs.tech/ngspice/design.ngspice
.lib /foss/pdks/gf180mcuD/libs.tech/ngspice/sm141064.ngspice typical
VDD Vdd 0 3.3
VSS Vss 0 0
IREF nref 0 1u
* <- se barre
VMEM Vmem 0 1.0
* tension del nodo de membrana
XR_m0 m0r m0r Vdd Vdd pfet_03v3 L=0.308u W=0.408u nf=1 ad='int((nf+1)/2) * W/nf * 0.18u' as='int((nf+2)/2) * W/nf * 0.18u' pd='2*int((nf+1)/2) * (W/nf + 0.18u)' ps='2*int((nf+2)/2) * (W/nf + 0.18u)' nrd='0.18u / W' nrs='0.18u / W' sa=0 sb=0 sd=0
VR_m0 nref m0r 0
XO_m0 m0o m0r Vdd Vdd pfet_03v3 L=1.105u W=3.257u nf=1 ad='int((nf+1)/2) * W/nf * 0.18u' as='int((nf+2)/2) * W/nf * 0.18u' pd='2*int((nf+1)/2) * (W/nf + 0.18u)' ps='2*int((nf+2)/2) * (W/nf + 0.18u)' nrd='0.18u / W' nrs='0.18u / W' sa=0 sb=0 sd=0
VO_m0 m0o Vmem 0
XR_m1 m1r m1r Vdd Vdd pfet_03v3 L=0.552u W=1.184u nf=1 ad='int((nf+1)/2) * W/nf * 0.18u' as='int((nf+2)/2) * W/nf * 0.18u' pd='2*int((nf+1)/2) * (W/nf + 0.18u)' ps='2*int((nf+2)/2) * (W/nf + 0.18u)' nrd='0.18u / W' nrs='0.18u / W' sa=0 sb=0 sd=0
VR_m1 nref m1r 0
XO_m1 m1o m1r Vdd Vdd pfet_03v3 L=3.024u W=3.97u nf=1 ad='int((nf+1)/2) * W/nf * 0.18u' as='int((nf+2)/2) * W/nf * 0.18u' pd='2*int((nf+1)/2) * (W/nf + 0.18u)' ps='2*int((nf+2)/2) * (W/nf + 0.18u)' nrd='0.18u / W' nrs='0.18u / W' sa=0 sb=0 sd=0
VO_m1 m1o Vmem 0
XR_m2 m2r m2r Vdd Vdd pfet_03v3 L=1.273u W=1.389u nf=1 ad='int((nf+1)/2) * W/nf * 0.18u' as='int((nf+2)/2) * W/nf * 0.18u' pd='2*int((nf+1)/2) * (W/nf + 0.18u)' ps='2*int((nf+2)/2) * (W/nf + 0.18u)' nrd='0.18u / W' nrs='0.18u / W' sa=0 sb=0 sd=0
VR_m2 nref m2r 0
XO_m2 m2o m2r Vdd Vdd pfet_03v3 L=0.44u W=0.232u nf=1 ad='int((nf+1)/2) * W/nf * 0.18u' as='int((nf+2)/2) * W/nf * 0.18u' pd='2*int((nf+1)/2) * (W/nf + 0.18u)' ps='2*int((nf+2)/2) * (W/nf + 0.18u)' nrd='0.18u / W' nrs='0.18u / W' sa=0 sb=0 sd=0
VO_m2 m2o Vmem 0
XR_m3 m3r m3r Vdd Vdd pfet_03v3 L=0.721u W=1.269u nf=1 ad='int((nf+1)/2) * W/nf * 0.18u' as='int((nf+2)/2) * W/nf * 0.18u' pd='2*int((nf+1)/2) * (W/nf + 0.18u)' ps='2*int((nf+2)/2) * (W/nf + 0.18u)' nrd='0.18u / W' nrs='0.18u / W' sa=0 sb=0 sd=0
VR_m3 nref m3r 0
XO_m3 m3o m3r Vdd Vdd pfet_03v3 L=1.79u W=0.313u nf=1 ad='int((nf+1)/2) * W/nf * 0.18u' as='int((nf+2)/2) * W/nf * 0.18u' pd='2*int((nf+1)/2) * (W/nf + 0.18u)' ps='2*int((nf+2)/2) * (W/nf + 0.18u)' nrd='0.18u / W' nrs='0.18u / W' sa=0 sb=0 sd=0
VO_m3 m3o Vmem 0
XR_m4 m4r m4r Vdd Vdd pfet_03v3 L=0.73u W=3.162u nf=1 ad='int((nf+1)/2) * W/nf * 0.18u' as='int((nf+2)/2) * W/nf * 0.18u' pd='2*int((nf+1)/2) * (W/nf + 0.18u)' ps='2*int((nf+2)/2) * (W/nf + 0.18u)' nrd='0.18u / W' nrs='0.18u / W' sa=0 sb=0 sd=0
VR_m4 nref m4r 0
XO_m4 m4o m4r Vdd Vdd pfet_03v3 L=5.464u W=1.958u nf=1 ad='int((nf+1)/2) * W/nf * 0.18u' as='int((nf+2)/2) * W/nf * 0.18u' pd='2*int((nf+1)/2) * (W/nf + 0.18u)' ps='2*int((nf+2)/2) * (W/nf + 0.18u)' nrd='0.18u / W' nrs='0.18u / W' sa=0 sb=0 sd=0
VO_m4 m4o Vmem 0
XR_m5 m5r m5r Vdd Vdd pfet_03v3 L=1.172u W=1.129u nf=1 ad='int((nf+1)/2) * W/nf * 0.18u' as='int((nf+2)/2) * W/nf * 0.18u' pd='2*int((nf+1)/2) * (W/nf + 0.18u)' ps='2*int((nf+2)/2) * (W/nf + 0.18u)' nrd='0.18u / W' nrs='0.18u / W' sa=0 sb=0 sd=0
VR_m5 nref m5r 0
XO_m5 m5o m5r Vdd Vdd pfet_03v3 L=1.926u W=0.319u nf=1 ad='int((nf+1)/2) * W/nf * 0.18u' as='int((nf+2)/2) * W/nf * 0.18u' pd='2*int((nf+1)/2) * (W/nf + 0.18u)' ps='2*int((nf+2)/2) * (W/nf + 0.18u)' nrd='0.18u / W' nrs='0.18u / W' sa=0 sb=0 sd=0
VO_m5 m5o Vmem 0
XR_m6 m6r m6r Vdd Vdd pfet_03v3 L=3.296u W=0.568u nf=1 ad='int((nf+1)/2) * W/nf * 0.18u' as='int((nf+2)/2) * W/nf * 0.18u' pd='2*int((nf+1)/2) * (W/nf + 0.18u)' ps='2*int((nf+2)/2) * (W/nf + 0.18u)' nrd='0.18u / W' nrs='0.18u / W' sa=0 sb=0 sd=0
VR_m6 nref m6r 0
XO_m6 m6o m6r Vdd Vdd pfet_03v3 L=1.727u W=0.892u nf=1 ad='int((nf+1)/2) * W/nf * 0.18u' as='int((nf+2)/2) * W/nf * 0.18u' pd='2*int((nf+1)/2) * (W/nf + 0.18u)' ps='2*int((nf+2)/2) * (W/nf + 0.18u)' nrd='0.18u / W' nrs='0.18u / W' sa=0 sb=0 sd=0
VO_m6 m6o Vmem 0
XR_m7 m7r m7r Vdd Vdd pfet_03v3 L=2.931u W=3.332u nf=1 ad='int((nf+1)/2) * W/nf * 0.18u' as='int((nf+2)/2) * W/nf * 0.18u' pd='2*int((nf+1)/2) * (W/nf + 0.18u)' ps='2*int((nf+2)/2) * (W/nf + 0.18u)' nrd='0.18u / W' nrs='0.18u / W' sa=0 sb=0 sd=0
VR_m7 nref m7r 0
XO_m7 m7o m7r Vdd Vdd pfet_03v3 L=0.672u W=2.438u nf=1 ad='int((nf+1)/2) * W/nf * 0.18u' as='int((nf+2)/2) * W/nf * 0.18u' pd='2*int((nf+1)/2) * (W/nf + 0.18u)' ps='2*int((nf+2)/2) * (W/nf + 0.18u)' nrd='0.18u / W' nrs='0.18u / W' sa=0 sb=0 sd=0
VO_m7 m7o Vmem 0
XR_m8 m8r m8r Vdd Vdd pfet_03v3 L=3.35u W=3.618u nf=1 ad='int((nf+1)/2) * W/nf * 0.18u' as='int((nf+2)/2) * W/nf * 0.18u' pd='2*int((nf+1)/2) * (W/nf + 0.18u)' ps='2*int((nf+2)/2) * (W/nf + 0.18u)' nrd='0.18u / W' nrs='0.18u / W' sa=0 sb=0 sd=0
VR_m8 nref m8r 0
XO_m8 m8o m8r Vdd Vdd pfet_03v3 L=0.375u W=0.395u nf=1 ad='int((nf+1)/2) * W/nf * 0.18u' as='int((nf+2)/2) * W/nf * 0.18u' pd='2*int((nf+1)/2) * (W/nf + 0.18u)' ps='2*int((nf+2)/2) * (W/nf + 0.18u)' nrd='0.18u / W' nrs='0.18u / W' sa=0 sb=0 sd=0
VO_m8 m8o Vmem 0
XR_m9 m9r m9r Vdd Vdd pfet_03v3 L=0.738u W=0.706u nf=1 ad='int((nf+1)/2) * W/nf * 0.18u' as='int((nf+2)/2) * W/nf * 0.18u' pd='2*int((nf+1)/2) * (W/nf + 0.18u)' ps='2*int((nf+2)/2) * (W/nf + 0.18u)' nrd='0.18u / W' nrs='0.18u / W' sa=0 sb=0 sd=0
VR_m9 nref m9r 0
XO_m9 m9o m9r Vdd Vdd pfet_03v3 L=0.456u W=0.289u nf=1 ad='int((nf+1)/2) * W/nf * 0.18u' as='int((nf+2)/2) * W/nf * 0.18u' pd='2*int((nf+1)/2) * (W/nf + 0.18u)' ps='2*int((nf+2)/2) * (W/nf + 0.18u)' nrd='0.18u / W' nrs='0.18u / W' sa=0 sb=0 sd=0
VO_m9 m9o Vmem 0
XR_m10 m10r m10r Vdd Vdd pfet_03v3 L=0.67u W=2.616u nf=1 ad='int((nf+1)/2) * W/nf * 0.18u' as='int((nf+2)/2) * W/nf * 0.18u' pd='2*int((nf+1)/2) * (W/nf + 0.18u)' ps='2*int((nf+2)/2) * (W/nf + 0.18u)' nrd='0.18u / W' nrs='0.18u / W' sa=0 sb=0 sd=0
VR_m10 nref m10r 0
XO_m10 m10o m10r Vdd Vdd pfet_03v3 L=3.572u W=3.44u nf=1 ad='int((nf+1)/2) * W/nf * 0.18u' as='int((nf+2)/2) * W/nf * 0.18u' pd='2*int((nf+1)/2) * (W/nf + 0.18u)' ps='2*int((nf+2)/2) * (W/nf + 0.18u)' nrd='0.18u / W' nrs='0.18u / W' sa=0 sb=0 sd=0
VO_m10 m10o Vmem 0
XR_m11 m11r m11r Vdd Vdd pfet_03v3 L=0.94u W=3.454u nf=1 ad='int((nf+1)/2) * W/nf * 0.18u' as='int((nf+2)/2) * W/nf * 0.18u' pd='2*int((nf+1)/2) * (W/nf + 0.18u)' ps='2*int((nf+2)/2) * (W/nf + 0.18u)' nrd='0.18u / W' nrs='0.18u / W' sa=0 sb=0 sd=0
VR_m11 nref m11r 0
XO_m11 m11o m11r Vdd Vdd pfet_03v3 L=2.496u W=1.584u nf=1 ad='int((nf+1)/2) * W/nf * 0.18u' as='int((nf+2)/2) * W/nf * 0.18u' pd='2*int((nf+1)/2) * (W/nf + 0.18u)' ps='2*int((nf+2)/2) * (W/nf + 0.18u)' nrd='0.18u / W' nrs='0.18u / W' sa=0 sb=0 sd=0
VO_m11 m11o Vmem 0
XR_m12 m12r m12r Vdd Vdd pfet_03v3 L=3.513u W=0.278u nf=1 ad='int((nf+1)/2) * W/nf * 0.18u' as='int((nf+2)/2) * W/nf * 0.18u' pd='2*int((nf+1)/2) * (W/nf + 0.18u)' ps='2*int((nf+2)/2) * (W/nf + 0.18u)' nrd='0.18u / W' nrs='0.18u / W' sa=0 sb=0 sd=0
VR_m12 nref m12r 0
XO_m12 m12o m12r Vdd Vdd pfet_03v3 L=0.342u W=3.516u nf=1 ad='int((nf+1)/2) * W/nf * 0.18u' as='int((nf+2)/2) * W/nf * 0.18u' pd='2*int((nf+1)/2) * (W/nf + 0.18u)' ps='2*int((nf+2)/2) * (W/nf + 0.18u)' nrd='0.18u / W' nrs='0.18u / W' sa=0 sb=0 sd=0
VO_m12 m12o Vmem 0
XR_m13 m13r m13r Vdd Vdd pfet_03v3 L=3.195u W=0.806u nf=1 ad='int((nf+1)/2) * W/nf * 0.18u' as='int((nf+2)/2) * W/nf * 0.18u' pd='2*int((nf+1)/2) * (W/nf + 0.18u)' ps='2*int((nf+2)/2) * (W/nf + 0.18u)' nrd='0.18u / W' nrs='0.18u / W' sa=0 sb=0 sd=0
VR_m13 nref m13r 0
XO_m13 m13o m13r Vdd Vdd pfet_03v3 L=2.47u W=0.458u nf=1 ad='int((nf+1)/2) * W/nf * 0.18u' as='int((nf+2)/2) * W/nf * 0.18u' pd='2*int((nf+1)/2) * (W/nf + 0.18u)' ps='2*int((nf+2)/2) * (W/nf + 0.18u)' nrd='0.18u / W' nrs='0.18u / W' sa=0 sb=0 sd=0
VO_m13 m13o Vmem 0
XR_m14 m14r m14r Vdd Vdd pfet_03v3 L=0.515u W=1.828u nf=1 ad='int((nf+1)/2) * W/nf * 0.18u' as='int((nf+2)/2) * W/nf * 0.18u' pd='2*int((nf+1)/2) * (W/nf + 0.18u)' ps='2*int((nf+2)/2) * (W/nf + 0.18u)' nrd='0.18u / W' nrs='0.18u / W' sa=0 sb=0 sd=0
VR_m14 nref m14r 0
XO_m14 m14o m14r Vdd Vdd pfet_03v3 L=2.709u W=1.028u nf=1 ad='int((nf+1)/2) * W/nf * 0.18u' as='int((nf+2)/2) * W/nf * 0.18u' pd='2*int((nf+1)/2) * (W/nf + 0.18u)' ps='2*int((nf+2)/2) * (W/nf + 0.18u)' nrd='0.18u / W' nrs='0.18u / W' sa=0 sb=0 sd=0
VO_m14 m14o Vmem 0
XR_m15 m15r m15r Vdd Vdd pfet_03v3 L=1.606u W=0.339u nf=1 ad='int((nf+1)/2) * W/nf * 0.18u' as='int((nf+2)/2) * W/nf * 0.18u' pd='2*int((nf+1)/2) * (W/nf + 0.18u)' ps='2*int((nf+2)/2) * (W/nf + 0.18u)' nrd='0.18u / W' nrs='0.18u / W' sa=0 sb=0 sd=0
VR_m15 nref m15r 0
XO_m15 m15o m15r Vdd Vdd pfet_03v3 L=3.522u W=1.312u nf=1 ad='int((nf+1)/2) * W/nf * 0.18u' as='int((nf+2)/2) * W/nf * 0.18u' pd='2*int((nf+1)/2) * (W/nf + 0.18u)' ps='2*int((nf+2)/2) * (W/nf + 0.18u)' nrd='0.18u / W' nrs='0.18u / W' sa=0 sb=0 sd=0
VO_m15 m15o Vmem 0
XR_m16 m16r m16r Vdd Vdd pfet_03v3 L=2.625u W=2.348u nf=1 ad='int((nf+1)/2) * W/nf * 0.18u' as='int((nf+2)/2) * W/nf * 0.18u' pd='2*int((nf+1)/2) * (W/nf + 0.18u)' ps='2*int((nf+2)/2) * (W/nf + 0.18u)' nrd='0.18u / W' nrs='0.18u / W' sa=0 sb=0 sd=0
VR_m16 nref m16r 0
XO_m16 m16o m16r Vdd Vdd pfet_03v3 L=1.699u W=3.923u nf=1 ad='int((nf+1)/2) * W/nf * 0.18u' as='int((nf+2)/2) * W/nf * 0.18u' pd='2*int((nf+1)/2) * (W/nf + 0.18u)' ps='2*int((nf+2)/2) * (W/nf + 0.18u)' nrd='0.18u / W' nrs='0.18u / W' sa=0 sb=0 sd=0
VO_m16 m16o Vmem 0
XR_m17 m17r m17r Vdd Vdd pfet_03v3 L=0.898u W=1.197u nf=1 ad='int((nf+1)/2) * W/nf * 0.18u' as='int((nf+2)/2) * W/nf * 0.18u' pd='2*int((nf+1)/2) * (W/nf + 0.18u)' ps='2*int((nf+2)/2) * (W/nf + 0.18u)' nrd='0.18u / W' nrs='0.18u / W' sa=0 sb=0 sd=0
VR_m17 nref m17r 0
XO_m17 m17o m17r Vdd Vdd pfet_03v3 L=0.543u W=0.251u nf=1 ad='int((nf+1)/2) * W/nf * 0.18u' as='int((nf+2)/2) * W/nf * 0.18u' pd='2*int((nf+1)/2) * (W/nf + 0.18u)' ps='2*int((nf+2)/2) * (W/nf + 0.18u)' nrd='0.18u / W' nrs='0.18u / W' sa=0 sb=0 sd=0
VO_m17 m17o Vmem 0
XR_m18 m18r m18r Vdd Vdd pfet_03v3 L=0.445u W=0.308u nf=1 ad='int((nf+1)/2) * W/nf * 0.18u' as='int((nf+2)/2) * W/nf * 0.18u' pd='2*int((nf+1)/2) * (W/nf + 0.18u)' ps='2*int((nf+2)/2) * (W/nf + 0.18u)' nrd='0.18u / W' nrs='0.18u / W' sa=0 sb=0 sd=0
VR_m18 nref m18r 0
XO_m18 m18o m18r Vdd Vdd pfet_03v3 L=1.55u W=2.174u nf=1 ad='int((nf+1)/2) * W/nf * 0.18u' as='int((nf+2)/2) * W/nf * 0.18u' pd='2*int((nf+1)/2) * (W/nf + 0.18u)' ps='2*int((nf+2)/2) * (W/nf + 0.18u)' nrd='0.18u / W' nrs='0.18u / W' sa=0 sb=0 sd=0
VO_m18 m18o Vmem 0
XR_m19 m19r m19r Vdd Vdd pfet_03v3 L=0.297u W=1.609u nf=1 ad='int((nf+1)/2) * W/nf * 0.18u' as='int((nf+2)/2) * W/nf * 0.18u' pd='2*int((nf+1)/2) * (W/nf + 0.18u)' ps='2*int((nf+2)/2) * (W/nf + 0.18u)' nrd='0.18u / W' nrs='0.18u / W' sa=0 sb=0 sd=0
VR_m19 nref m19r 0
XO_m19 m19o m19r Vdd Vdd pfet_03v3 L=2.626u W=0.454u nf=1 ad='int((nf+1)/2) * W/nf * 0.18u' as='int((nf+2)/2) * W/nf * 0.18u' pd='2*int((nf+1)/2) * (W/nf + 0.18u)' ps='2*int((nf+2)/2) * (W/nf + 0.18u)' nrd='0.18u / W' nrs='0.18u / W' sa=0 sb=0 sd=0
VO_m19 m19o Vmem 0
XR_m20 m20r m20r Vdd Vdd pfet_03v3 L=1.695u W=0.382u nf=1 ad='int((nf+1)/2) * W/nf * 0.18u' as='int((nf+2)/2) * W/nf * 0.18u' pd='2*int((nf+1)/2) * (W/nf + 0.18u)' ps='2*int((nf+2)/2) * (W/nf + 0.18u)' nrd='0.18u / W' nrs='0.18u / W' sa=0 sb=0 sd=0
VR_m20 nref m20r 0
XO_m20 m20o m20r Vdd Vdd pfet_03v3 L=1.634u W=0.457u nf=1 ad='int((nf+1)/2) * W/nf * 0.18u' as='int((nf+2)/2) * W/nf * 0.18u' pd='2*int((nf+1)/2) * (W/nf + 0.18u)' ps='2*int((nf+2)/2) * (W/nf + 0.18u)' nrd='0.18u / W' nrs='0.18u / W' sa=0 sb=0 sd=0
VO_m20 m20o Vmem 0
XR_m21 m21r m21r Vdd Vdd pfet_03v3 L=1.482u W=1.057u nf=1 ad='int((nf+1)/2) * W/nf * 0.18u' as='int((nf+2)/2) * W/nf * 0.18u' pd='2*int((nf+1)/2) * (W/nf + 0.18u)' ps='2*int((nf+2)/2) * (W/nf + 0.18u)' nrd='0.18u / W' nrs='0.18u / W' sa=0 sb=0 sd=0
VR_m21 nref m21r 0
XO_m21 m21o m21r Vdd Vdd pfet_03v3 L=2.81u W=0.731u nf=1 ad='int((nf+1)/2) * W/nf * 0.18u' as='int((nf+2)/2) * W/nf * 0.18u' pd='2*int((nf+1)/2) * (W/nf + 0.18u)' ps='2*int((nf+2)/2) * (W/nf + 0.18u)' nrd='0.18u / W' nrs='0.18u / W' sa=0 sb=0 sd=0
VO_m21 m21o Vmem 0
XR_m22 m22r m22r Vdd Vdd pfet_03v3 L=0.622u W=0.289u nf=1 ad='int((nf+1)/2) * W/nf * 0.18u' as='int((nf+2)/2) * W/nf * 0.18u' pd='2*int((nf+1)/2) * (W/nf + 0.18u)' ps='2*int((nf+2)/2) * (W/nf + 0.18u)' nrd='0.18u / W' nrs='0.18u / W' sa=0 sb=0 sd=0
VR_m22 nref m22r 0
XO_m22 m22o m22r Vdd Vdd pfet_03v3 L=0.517u W=0.844u nf=1 ad='int((nf+1)/2) * W/nf * 0.18u' as='int((nf+2)/2) * W/nf * 0.18u' pd='2*int((nf+1)/2) * (W/nf + 0.18u)' ps='2*int((nf+2)/2) * (W/nf + 0.18u)' nrd='0.18u / W' nrs='0.18u / W' sa=0 sb=0 sd=0
VO_m22 m22o Vmem 0
XR_m23 m23r m23r Vdd Vdd pfet_03v3 L=0.586u W=0.76u nf=1 ad='int((nf+1)/2) * W/nf * 0.18u' as='int((nf+2)/2) * W/nf * 0.18u' pd='2*int((nf+1)/2) * (W/nf + 0.18u)' ps='2*int((nf+2)/2) * (W/nf + 0.18u)' nrd='0.18u / W' nrs='0.18u / W' sa=0 sb=0 sd=0
VR_m23 nref m23r 0
XO_m23 m23o m23r Vdd Vdd pfet_03v3 L=2.391u W=0.47u nf=1 ad='int((nf+1)/2) * W/nf * 0.18u' as='int((nf+2)/2) * W/nf * 0.18u' pd='2*int((nf+1)/2) * (W/nf + 0.18u)' ps='2*int((nf+2)/2) * (W/nf + 0.18u)' nrd='0.18u / W' nrs='0.18u / W' sa=0 sb=0 sd=0
VO_m23 m23o Vmem 0
XR_m24 m24r m24r Vdd Vdd pfet_03v3 L=0.452u W=0.226u nf=1 ad='int((nf+1)/2) * W/nf * 0.18u' as='int((nf+2)/2) * W/nf * 0.18u' pd='2*int((nf+1)/2) * (W/nf + 0.18u)' ps='2*int((nf+2)/2) * (W/nf + 0.18u)' nrd='0.18u / W' nrs='0.18u / W' sa=0 sb=0 sd=0
VR_m24 nref m24r 0
XO_m24 m24o m24r Vdd Vdd pfet_03v3 L=1.594u W=2.605u nf=1 ad='int((nf+1)/2) * W/nf * 0.18u' as='int((nf+2)/2) * W/nf * 0.18u' pd='2*int((nf+1)/2) * (W/nf + 0.18u)' ps='2*int((nf+2)/2) * (W/nf + 0.18u)' nrd='0.18u / W' nrs='0.18u / W' sa=0 sb=0 sd=0
VO_m24 m24o Vmem 0
XR_m25 m25r m25r Vdd Vdd pfet_03v3 L=2.653u W=3.686u nf=1 ad='int((nf+1)/2) * W/nf * 0.18u' as='int((nf+2)/2) * W/nf * 0.18u' pd='2*int((nf+1)/2) * (W/nf + 0.18u)' ps='2*int((nf+2)/2) * (W/nf + 0.18u)' nrd='0.18u / W' nrs='0.18u / W' sa=0 sb=0 sd=0
VR_m25 nref m25r 0
XO_m25 m25o m25r Vdd Vdd pfet_03v3 L=1.915u W=0.386u nf=1 ad='int((nf+1)/2) * W/nf * 0.18u' as='int((nf+2)/2) * W/nf * 0.18u' pd='2*int((nf+1)/2) * (W/nf + 0.18u)' ps='2*int((nf+2)/2) * (W/nf + 0.18u)' nrd='0.18u / W' nrs='0.18u / W' sa=0 sb=0 sd=0
VO_m25 m25o Vmem 0
XR_m26 m26r m26r Vdd Vdd pfet_03v3 L=0.606u W=0.68u nf=1 ad='int((nf+1)/2) * W/nf * 0.18u' as='int((nf+2)/2) * W/nf * 0.18u' pd='2*int((nf+1)/2) * (W/nf + 0.18u)' ps='2*int((nf+2)/2) * (W/nf + 0.18u)' nrd='0.18u / W' nrs='0.18u / W' sa=0 sb=0 sd=0
VR_m26 nref m26r 0
XO_m26 m26o m26r Vdd Vdd pfet_03v3 L=1.708u W=2.579u nf=1 ad='int((nf+1)/2) * W/nf * 0.18u' as='int((nf+2)/2) * W/nf * 0.18u' pd='2*int((nf+1)/2) * (W/nf + 0.18u)' ps='2*int((nf+2)/2) * (W/nf + 0.18u)' nrd='0.18u / W' nrs='0.18u / W' sa=0 sb=0 sd=0
VO_m26 m26o Vmem 0
XR_m27 m27r m27r Vdd Vdd pfet_03v3 L=0.35u W=2.154u nf=1 ad='int((nf+1)/2) * W/nf * 0.18u' as='int((nf+2)/2) * W/nf * 0.18u' pd='2*int((nf+1)/2) * (W/nf + 0.18u)' ps='2*int((nf+2)/2) * (W/nf + 0.18u)' nrd='0.18u / W' nrs='0.18u / W' sa=0 sb=0 sd=0
VR_m27 nref m27r 0
XO_m27 m27o m27r Vdd Vdd pfet_03v3 L=6.56u W=3.971u nf=1 ad='int((nf+1)/2) * W/nf * 0.18u' as='int((nf+2)/2) * W/nf * 0.18u' pd='2*int((nf+1)/2) * (W/nf + 0.18u)' ps='2*int((nf+2)/2) * (W/nf + 0.18u)' nrd='0.18u / W' nrs='0.18u / W' sa=0 sb=0 sd=0
VO_m27 m27o Vmem 0
XR_m28 m28r m28r Vdd Vdd pfet_03v3 L=0.325u W=1.862u nf=1 ad='int((nf+1)/2) * W/nf * 0.18u' as='int((nf+2)/2) * W/nf * 0.18u' pd='2*int((nf+1)/2) * (W/nf + 0.18u)' ps='2*int((nf+2)/2) * (W/nf + 0.18u)' nrd='0.18u / W' nrs='0.18u / W' sa=0 sb=0 sd=0
VR_m28 nref m28r 0
XO_m28 m28o m28r Vdd Vdd pfet_03v3 L=7.077u W=0.394u nf=1 ad='int((nf+1)/2) * W/nf * 0.18u' as='int((nf+2)/2) * W/nf * 0.18u' pd='2*int((nf+1)/2) * (W/nf + 0.18u)' ps='2*int((nf+2)/2) * (W/nf + 0.18u)' nrd='0.18u / W' nrs='0.18u / W' sa=0 sb=0 sd=0
VO_m28 m28o Vmem 0
XR_m29 m29r m29r Vdd Vdd pfet_03v3 L=0.513u W=1.99u nf=1 ad='int((nf+1)/2) * W/nf * 0.18u' as='int((nf+2)/2) * W/nf * 0.18u' pd='2*int((nf+1)/2) * (W/nf + 0.18u)' ps='2*int((nf+2)/2) * (W/nf + 0.18u)' nrd='0.18u / W' nrs='0.18u / W' sa=0 sb=0 sd=0
VR_m29 nref m29r 0
XO_m29 m29o m29r Vdd Vdd pfet_03v3 L=0.831u W=2.989u nf=1 ad='int((nf+1)/2) * W/nf * 0.18u' as='int((nf+2)/2) * W/nf * 0.18u' pd='2*int((nf+1)/2) * (W/nf + 0.18u)' ps='2*int((nf+2)/2) * (W/nf + 0.18u)' nrd='0.18u / W' nrs='0.18u / W' sa=0 sb=0 sd=0
VO_m29 m29o Vmem 0
XR_m30 m30r m30r Vdd Vdd pfet_03v3 L=0.62u W=0.802u nf=1 ad='int((nf+1)/2) * W/nf * 0.18u' as='int((nf+2)/2) * W/nf * 0.18u' pd='2*int((nf+1)/2) * (W/nf + 0.18u)' ps='2*int((nf+2)/2) * (W/nf + 0.18u)' nrd='0.18u / W' nrs='0.18u / W' sa=0 sb=0 sd=0
VR_m30 nref m30r 0
XO_m30 m30o m30r Vdd Vdd pfet_03v3 L=1.177u W=1.964u nf=1 ad='int((nf+1)/2) * W/nf * 0.18u' as='int((nf+2)/2) * W/nf * 0.18u' pd='2*int((nf+1)/2) * (W/nf + 0.18u)' ps='2*int((nf+2)/2) * (W/nf + 0.18u)' nrd='0.18u / W' nrs='0.18u / W' sa=0 sb=0 sd=0
VO_m30 m30o Vmem 0
XR_m31 m31r m31r Vdd Vdd pfet_03v3 L=3.434u W=0.912u nf=1 ad='int((nf+1)/2) * W/nf * 0.18u' as='int((nf+2)/2) * W/nf * 0.18u' pd='2*int((nf+1)/2) * (W/nf + 0.18u)' ps='2*int((nf+2)/2) * (W/nf + 0.18u)' nrd='0.18u / W' nrs='0.18u / W' sa=0 sb=0 sd=0
VR_m31 nref m31r 0
XO_m31 m31o m31r Vdd Vdd pfet_03v3 L=2.38u W=0.82u nf=1 ad='int((nf+1)/2) * W/nf * 0.18u' as='int((nf+2)/2) * W/nf * 0.18u' pd='2*int((nf+1)/2) * (W/nf + 0.18u)' ps='2*int((nf+2)/2) * (W/nf + 0.18u)' nrd='0.18u / W' nrs='0.18u / W' sa=0 sb=0 sd=0
VO_m31 m31o Vmem 0
XR_m32 m32r m32r Vdd Vdd pfet_03v3 L=3.058u W=0.615u nf=1 ad='int((nf+1)/2) * W/nf * 0.18u' as='int((nf+2)/2) * W/nf * 0.18u' pd='2*int((nf+1)/2) * (W/nf + 0.18u)' ps='2*int((nf+2)/2) * (W/nf + 0.18u)' nrd='0.18u / W' nrs='0.18u / W' sa=0 sb=0 sd=0
VR_m32 nref m32r 0
XO_m32 m32o m32r Vdd Vdd pfet_03v3 L=2.654u W=3.784u nf=1 ad='int((nf+1)/2) * W/nf * 0.18u' as='int((nf+2)/2) * W/nf * 0.18u' pd='2*int((nf+1)/2) * (W/nf + 0.18u)' ps='2*int((nf+2)/2) * (W/nf + 0.18u)' nrd='0.18u / W' nrs='0.18u / W' sa=0 sb=0 sd=0
VO_m32 m32o Vmem 0
XR_m33 m33r m33r Vdd Vdd pfet_03v3 L=0.489u W=1.85u nf=1 ad='int((nf+1)/2) * W/nf * 0.18u' as='int((nf+2)/2) * W/nf * 0.18u' pd='2*int((nf+1)/2) * (W/nf + 0.18u)' ps='2*int((nf+2)/2) * (W/nf + 0.18u)' nrd='0.18u / W' nrs='0.18u / W' sa=0 sb=0 sd=0
VR_m33 nref m33r 0
XO_m33 m33o m33r Vdd Vdd pfet_03v3 L=5.722u W=2.721u nf=1 ad='int((nf+1)/2) * W/nf * 0.18u' as='int((nf+2)/2) * W/nf * 0.18u' pd='2*int((nf+1)/2) * (W/nf + 0.18u)' ps='2*int((nf+2)/2) * (W/nf + 0.18u)' nrd='0.18u / W' nrs='0.18u / W' sa=0 sb=0 sd=0
VO_m33 m33o Vmem 0
XR_m34 m34r m34r Vdd Vdd pfet_03v3 L=3.039u W=0.677u nf=1 ad='int((nf+1)/2) * W/nf * 0.18u' as='int((nf+2)/2) * W/nf * 0.18u' pd='2*int((nf+1)/2) * (W/nf + 0.18u)' ps='2*int((nf+2)/2) * (W/nf + 0.18u)' nrd='0.18u / W' nrs='0.18u / W' sa=0 sb=0 sd=0
VR_m34 nref m34r 0
XO_m34 m34o m34r Vdd Vdd pfet_03v3 L=1.099u W=0.632u nf=1 ad='int((nf+1)/2) * W/nf * 0.18u' as='int((nf+2)/2) * W/nf * 0.18u' pd='2*int((nf+1)/2) * (W/nf + 0.18u)' ps='2*int((nf+2)/2) * (W/nf + 0.18u)' nrd='0.18u / W' nrs='0.18u / W' sa=0 sb=0 sd=0
VO_m34 m34o Vmem 0
XR_m35 m35r m35r Vdd Vdd pfet_03v3 L=0.396u W=0.486u nf=1 ad='int((nf+1)/2) * W/nf * 0.18u' as='int((nf+2)/2) * W/nf * 0.18u' pd='2*int((nf+1)/2) * (W/nf + 0.18u)' ps='2*int((nf+2)/2) * (W/nf + 0.18u)' nrd='0.18u / W' nrs='0.18u / W' sa=0 sb=0 sd=0
VR_m35 nref m35r 0
XO_m35 m35o m35r Vdd Vdd pfet_03v3 L=0.576u W=3.594u nf=1 ad='int((nf+1)/2) * W/nf * 0.18u' as='int((nf+2)/2) * W/nf * 0.18u' pd='2*int((nf+1)/2) * (W/nf + 0.18u)' ps='2*int((nf+2)/2) * (W/nf + 0.18u)' nrd='0.18u / W' nrs='0.18u / W' sa=0 sb=0 sd=0
VO_m35 m35o Vmem 0
XR_m36 m36r m36r Vdd Vdd pfet_03v3 L=0.445u W=1.231u nf=1 ad='int((nf+1)/2) * W/nf * 0.18u' as='int((nf+2)/2) * W/nf * 0.18u' pd='2*int((nf+1)/2) * (W/nf + 0.18u)' ps='2*int((nf+2)/2) * (W/nf + 0.18u)' nrd='0.18u / W' nrs='0.18u / W' sa=0 sb=0 sd=0
VR_m36 nref m36r 0
XO_m36 m36o m36r Vdd Vdd pfet_03v3 L=1.377u W=0.462u nf=1 ad='int((nf+1)/2) * W/nf * 0.18u' as='int((nf+2)/2) * W/nf * 0.18u' pd='2*int((nf+1)/2) * (W/nf + 0.18u)' ps='2*int((nf+2)/2) * (W/nf + 0.18u)' nrd='0.18u / W' nrs='0.18u / W' sa=0 sb=0 sd=0
VO_m36 m36o Vmem 0
XR_m37 m37r m37r Vdd Vdd pfet_03v3 L=0.655u W=1.754u nf=1 ad='int((nf+1)/2) * W/nf * 0.18u' as='int((nf+2)/2) * W/nf * 0.18u' pd='2*int((nf+1)/2) * (W/nf + 0.18u)' ps='2*int((nf+2)/2) * (W/nf + 0.18u)' nrd='0.18u / W' nrs='0.18u / W' sa=0 sb=0 sd=0
VR_m37 nref m37r 0
XO_m37 m37o m37r Vdd Vdd pfet_03v3 L=5.432u W=2.165u nf=1 ad='int((nf+1)/2) * W/nf * 0.18u' as='int((nf+2)/2) * W/nf * 0.18u' pd='2*int((nf+1)/2) * (W/nf + 0.18u)' ps='2*int((nf+2)/2) * (W/nf + 0.18u)' nrd='0.18u / W' nrs='0.18u / W' sa=0 sb=0 sd=0
VO_m37 m37o Vmem 0
XR_m38 m38r m38r Vdd Vdd pfet_03v3 L=2.873u W=3.28u nf=1 ad='int((nf+1)/2) * W/nf * 0.18u' as='int((nf+2)/2) * W/nf * 0.18u' pd='2*int((nf+1)/2) * (W/nf + 0.18u)' ps='2*int((nf+2)/2) * (W/nf + 0.18u)' nrd='0.18u / W' nrs='0.18u / W' sa=0 sb=0 sd=0
VR_m38 nref m38r 0
XO_m38 m38o m38r Vdd Vdd pfet_03v3 L=5.138u W=0.432u nf=1 ad='int((nf+1)/2) * W/nf * 0.18u' as='int((nf+2)/2) * W/nf * 0.18u' pd='2*int((nf+1)/2) * (W/nf + 0.18u)' ps='2*int((nf+2)/2) * (W/nf + 0.18u)' nrd='0.18u / W' nrs='0.18u / W' sa=0 sb=0 sd=0
VO_m38 m38o Vmem 0
XR_m39 m39r m39r Vdd Vdd pfet_03v3 L=0.458u W=3.433u nf=1 ad='int((nf+1)/2) * W/nf * 0.18u' as='int((nf+2)/2) * W/nf * 0.18u' pd='2*int((nf+1)/2) * (W/nf + 0.18u)' ps='2*int((nf+2)/2) * (W/nf + 0.18u)' nrd='0.18u / W' nrs='0.18u / W' sa=0 sb=0 sd=0
VR_m39 nref m39r 0
XO_m39 m39o m39r Vdd Vdd pfet_03v3 L=0.964u W=2.14u nf=1 ad='int((nf+1)/2) * W/nf * 0.18u' as='int((nf+2)/2) * W/nf * 0.18u' pd='2*int((nf+1)/2) * (W/nf + 0.18u)' ps='2*int((nf+2)/2) * (W/nf + 0.18u)' nrd='0.18u / W' nrs='0.18u / W' sa=0 sb=0 sd=0
VO_m39 m39o Vmem 0
XR_m40 m40r m40r Vdd Vdd pfet_03v3 L=0.932u W=0.303u nf=1 ad='int((nf+1)/2) * W/nf * 0.18u' as='int((nf+2)/2) * W/nf * 0.18u' pd='2*int((nf+1)/2) * (W/nf + 0.18u)' ps='2*int((nf+2)/2) * (W/nf + 0.18u)' nrd='0.18u / W' nrs='0.18u / W' sa=0 sb=0 sd=0
VR_m40 nref m40r 0
XO_m40 m40o m40r Vdd Vdd pfet_03v3 L=0.61u W=0.247u nf=1 ad='int((nf+1)/2) * W/nf * 0.18u' as='int((nf+2)/2) * W/nf * 0.18u' pd='2*int((nf+1)/2) * (W/nf + 0.18u)' ps='2*int((nf+2)/2) * (W/nf + 0.18u)' nrd='0.18u / W' nrs='0.18u / W' sa=0 sb=0 sd=0
VO_m40 m40o Vmem 0
XR_m41 m41r m41r Vdd Vdd pfet_03v3 L=0.836u W=0.774u nf=1 ad='int((nf+1)/2) * W/nf * 0.18u' as='int((nf+2)/2) * W/nf * 0.18u' pd='2*int((nf+1)/2) * (W/nf + 0.18u)' ps='2*int((nf+2)/2) * (W/nf + 0.18u)' nrd='0.18u / W' nrs='0.18u / W' sa=0 sb=0 sd=0
VR_m41 nref m41r 0
XO_m41 m41o m41r Vdd Vdd pfet_03v3 L=3.196u W=0.492u nf=1 ad='int((nf+1)/2) * W/nf * 0.18u' as='int((nf+2)/2) * W/nf * 0.18u' pd='2*int((nf+1)/2) * (W/nf + 0.18u)' ps='2*int((nf+2)/2) * (W/nf + 0.18u)' nrd='0.18u / W' nrs='0.18u / W' sa=0 sb=0 sd=0
VO_m41 m41o Vmem 0
XR_m42 m42r m42r Vdd Vdd pfet_03v3 L=1.381u W=0.343u nf=1 ad='int((nf+1)/2) * W/nf * 0.18u' as='int((nf+2)/2) * W/nf * 0.18u' pd='2*int((nf+1)/2) * (W/nf + 0.18u)' ps='2*int((nf+2)/2) * (W/nf + 0.18u)' nrd='0.18u / W' nrs='0.18u / W' sa=0 sb=0 sd=0
VR_m42 nref m42r 0
XO_m42 m42o m42r Vdd Vdd pfet_03v3 L=2.223u W=0.664u nf=1 ad='int((nf+1)/2) * W/nf * 0.18u' as='int((nf+2)/2) * W/nf * 0.18u' pd='2*int((nf+1)/2) * (W/nf + 0.18u)' ps='2*int((nf+2)/2) * (W/nf + 0.18u)' nrd='0.18u / W' nrs='0.18u / W' sa=0 sb=0 sd=0
VO_m42 m42o Vmem 0
XR_m43 m43r m43r Vdd Vdd pfet_03v3 L=2.364u W=1.47u nf=1 ad='int((nf+1)/2) * W/nf * 0.18u' as='int((nf+2)/2) * W/nf * 0.18u' pd='2*int((nf+1)/2) * (W/nf + 0.18u)' ps='2*int((nf+2)/2) * (W/nf + 0.18u)' nrd='0.18u / W' nrs='0.18u / W' sa=0 sb=0 sd=0
VR_m43 nref m43r 0
XO_m43 m43o m43r Vdd Vdd pfet_03v3 L=3.963u W=0.29u nf=1 ad='int((nf+1)/2) * W/nf * 0.18u' as='int((nf+2)/2) * W/nf * 0.18u' pd='2*int((nf+1)/2) * (W/nf + 0.18u)' ps='2*int((nf+2)/2) * (W/nf + 0.18u)' nrd='0.18u / W' nrs='0.18u / W' sa=0 sb=0 sd=0
VO_m43 m43o Vmem 0
XR_m44 m44r m44r Vdd Vdd pfet_03v3 L=1.462u W=2.806u nf=1 ad='int((nf+1)/2) * W/nf * 0.18u' as='int((nf+2)/2) * W/nf * 0.18u' pd='2*int((nf+1)/2) * (W/nf + 0.18u)' ps='2*int((nf+2)/2) * (W/nf + 0.18u)' nrd='0.18u / W' nrs='0.18u / W' sa=0 sb=0 sd=0
VR_m44 nref m44r 0
XO_m44 m44o m44r Vdd Vdd pfet_03v3 L=1.165u W=0.411u nf=1 ad='int((nf+1)/2) * W/nf * 0.18u' as='int((nf+2)/2) * W/nf * 0.18u' pd='2*int((nf+1)/2) * (W/nf + 0.18u)' ps='2*int((nf+2)/2) * (W/nf + 0.18u)' nrd='0.18u / W' nrs='0.18u / W' sa=0 sb=0 sd=0
VO_m44 m44o Vmem 0
XR_m45 m45r m45r Vdd Vdd pfet_03v3 L=0.309u W=1.273u nf=1 ad='int((nf+1)/2) * W/nf * 0.18u' as='int((nf+2)/2) * W/nf * 0.18u' pd='2*int((nf+1)/2) * (W/nf + 0.18u)' ps='2*int((nf+2)/2) * (W/nf + 0.18u)' nrd='0.18u / W' nrs='0.18u / W' sa=0 sb=0 sd=0
VR_m45 nref m45r 0
XO_m45 m45o m45r Vdd Vdd pfet_03v3 L=2.139u W=0.853u nf=1 ad='int((nf+1)/2) * W/nf * 0.18u' as='int((nf+2)/2) * W/nf * 0.18u' pd='2*int((nf+1)/2) * (W/nf + 0.18u)' ps='2*int((nf+2)/2) * (W/nf + 0.18u)' nrd='0.18u / W' nrs='0.18u / W' sa=0 sb=0 sd=0
VO_m45 m45o Vmem 0
XR_m46 m46r m46r Vdd Vdd pfet_03v3 L=0.513u W=3.944u nf=1 ad='int((nf+1)/2) * W/nf * 0.18u' as='int((nf+2)/2) * W/nf * 0.18u' pd='2*int((nf+1)/2) * (W/nf + 0.18u)' ps='2*int((nf+2)/2) * (W/nf + 0.18u)' nrd='0.18u / W' nrs='0.18u / W' sa=0 sb=0 sd=0
VR_m46 nref m46r 0
XO_m46 m46o m46r Vdd Vdd pfet_03v3 L=0.836u W=2.319u nf=1 ad='int((nf+1)/2) * W/nf * 0.18u' as='int((nf+2)/2) * W/nf * 0.18u' pd='2*int((nf+1)/2) * (W/nf + 0.18u)' ps='2*int((nf+2)/2) * (W/nf + 0.18u)' nrd='0.18u / W' nrs='0.18u / W' sa=0 sb=0 sd=0
VO_m46 m46o Vmem 0
XR_m47 m47r m47r Vdd Vdd pfet_03v3 L=0.461u W=1.34u nf=1 ad='int((nf+1)/2) * W/nf * 0.18u' as='int((nf+2)/2) * W/nf * 0.18u' pd='2*int((nf+1)/2) * (W/nf + 0.18u)' ps='2*int((nf+2)/2) * (W/nf + 0.18u)' nrd='0.18u / W' nrs='0.18u / W' sa=0 sb=0 sd=0
VR_m47 nref m47r 0
XO_m47 m47o m47r Vdd Vdd pfet_03v3 L=3.115u W=0.63u nf=1 ad='int((nf+1)/2) * W/nf * 0.18u' as='int((nf+2)/2) * W/nf * 0.18u' pd='2*int((nf+1)/2) * (W/nf + 0.18u)' ps='2*int((nf+2)/2) * (W/nf + 0.18u)' nrd='0.18u / W' nrs='0.18u / W' sa=0 sb=0 sd=0
VO_m47 m47o Vmem 0
XR_m48 m48r m48r Vdd Vdd pfet_03v3 L=0.71u W=1.93u nf=1 ad='int((nf+1)/2) * W/nf * 0.18u' as='int((nf+2)/2) * W/nf * 0.18u' pd='2*int((nf+1)/2) * (W/nf + 0.18u)' ps='2*int((nf+2)/2) * (W/nf + 0.18u)' nrd='0.18u / W' nrs='0.18u / W' sa=0 sb=0 sd=0
VR_m48 nref m48r 0
XO_m48 m48o m48r Vdd Vdd pfet_03v3 L=0.986u W=2.222u nf=1 ad='int((nf+1)/2) * W/nf * 0.18u' as='int((nf+2)/2) * W/nf * 0.18u' pd='2*int((nf+1)/2) * (W/nf + 0.18u)' ps='2*int((nf+2)/2) * (W/nf + 0.18u)' nrd='0.18u / W' nrs='0.18u / W' sa=0 sb=0 sd=0
VO_m48 m48o Vmem 0
XR_m49 m49r m49r Vdd Vdd pfet_03v3 L=0.775u W=1.38u nf=1 ad='int((nf+1)/2) * W/nf * 0.18u' as='int((nf+2)/2) * W/nf * 0.18u' pd='2*int((nf+1)/2) * (W/nf + 0.18u)' ps='2*int((nf+2)/2) * (W/nf + 0.18u)' nrd='0.18u / W' nrs='0.18u / W' sa=0 sb=0 sd=0
VR_m49 nref m49r 0
XO_m49 m49o m49r Vdd Vdd pfet_03v3 L=6.137u W=1.216u nf=1 ad='int((nf+1)/2) * W/nf * 0.18u' as='int((nf+2)/2) * W/nf * 0.18u' pd='2*int((nf+1)/2) * (W/nf + 0.18u)' ps='2*int((nf+2)/2) * (W/nf + 0.18u)' nrd='0.18u / W' nrs='0.18u / W' sa=0 sb=0 sd=0
VO_m49 m49o Vmem 0
XR_m50 m50r m50r Vdd Vdd pfet_03v3 L=1.023u W=1.207u nf=1 ad='int((nf+1)/2) * W/nf * 0.18u' as='int((nf+2)/2) * W/nf * 0.18u' pd='2*int((nf+1)/2) * (W/nf + 0.18u)' ps='2*int((nf+2)/2) * (W/nf + 0.18u)' nrd='0.18u / W' nrs='0.18u / W' sa=0 sb=0 sd=0
VR_m50 nref m50r 0
XO_m50 m50o m50r Vdd Vdd pfet_03v3 L=4.569u W=0.651u nf=1 ad='int((nf+1)/2) * W/nf * 0.18u' as='int((nf+2)/2) * W/nf * 0.18u' pd='2*int((nf+1)/2) * (W/nf + 0.18u)' ps='2*int((nf+2)/2) * (W/nf + 0.18u)' nrd='0.18u / W' nrs='0.18u / W' sa=0 sb=0 sd=0
VO_m50 m50o Vmem 0
XR_m51 m51r m51r Vdd Vdd pfet_03v3 L=0.557u W=0.222u nf=1 ad='int((nf+1)/2) * W/nf * 0.18u' as='int((nf+2)/2) * W/nf * 0.18u' pd='2*int((nf+1)/2) * (W/nf + 0.18u)' ps='2*int((nf+2)/2) * (W/nf + 0.18u)' nrd='0.18u / W' nrs='0.18u / W' sa=0 sb=0 sd=0
VR_m51 nref m51r 0
XO_m51 m51o m51r Vdd Vdd pfet_03v3 L=0.462u W=0.478u nf=1 ad='int((nf+1)/2) * W/nf * 0.18u' as='int((nf+2)/2) * W/nf * 0.18u' pd='2*int((nf+1)/2) * (W/nf + 0.18u)' ps='2*int((nf+2)/2) * (W/nf + 0.18u)' nrd='0.18u / W' nrs='0.18u / W' sa=0 sb=0 sd=0
VO_m51 m51o Vmem 0
XR_m52 m52r m52r Vdd Vdd pfet_03v3 L=0.481u W=1.119u nf=1 ad='int((nf+1)/2) * W/nf * 0.18u' as='int((nf+2)/2) * W/nf * 0.18u' pd='2*int((nf+1)/2) * (W/nf + 0.18u)' ps='2*int((nf+2)/2) * (W/nf + 0.18u)' nrd='0.18u / W' nrs='0.18u / W' sa=0 sb=0 sd=0
VR_m52 nref m52r 0
XO_m52 m52o m52r Vdd Vdd pfet_03v3 L=0.344u W=2.871u nf=1 ad='int((nf+1)/2) * W/nf * 0.18u' as='int((nf+2)/2) * W/nf * 0.18u' pd='2*int((nf+1)/2) * (W/nf + 0.18u)' ps='2*int((nf+2)/2) * (W/nf + 0.18u)' nrd='0.18u / W' nrs='0.18u / W' sa=0 sb=0 sd=0
VO_m52 m52o Vmem 0
XR_m53 m53r m53r Vdd Vdd pfet_03v3 L=2.669u W=3.856u nf=1 ad='int((nf+1)/2) * W/nf * 0.18u' as='int((nf+2)/2) * W/nf * 0.18u' pd='2*int((nf+1)/2) * (W/nf + 0.18u)' ps='2*int((nf+2)/2) * (W/nf + 0.18u)' nrd='0.18u / W' nrs='0.18u / W' sa=0 sb=0 sd=0
VR_m53 nref m53r 0
XO_m53 m53o m53r Vdd Vdd pfet_03v3 L=0.643u W=3.734u nf=1 ad='int((nf+1)/2) * W/nf * 0.18u' as='int((nf+2)/2) * W/nf * 0.18u' pd='2*int((nf+1)/2) * (W/nf + 0.18u)' ps='2*int((nf+2)/2) * (W/nf + 0.18u)' nrd='0.18u / W' nrs='0.18u / W' sa=0 sb=0 sd=0
VO_m53 m53o Vmem 0
XR_m54 m54r m54r Vdd Vdd pfet_03v3 L=0.956u W=1.759u nf=1 ad='int((nf+1)/2) * W/nf * 0.18u' as='int((nf+2)/2) * W/nf * 0.18u' pd='2*int((nf+1)/2) * (W/nf + 0.18u)' ps='2*int((nf+2)/2) * (W/nf + 0.18u)' nrd='0.18u / W' nrs='0.18u / W' sa=0 sb=0 sd=0
VR_m54 nref m54r 0
XO_m54 m54o m54r Vdd Vdd pfet_03v3 L=5.467u W=0.326u nf=1 ad='int((nf+1)/2) * W/nf * 0.18u' as='int((nf+2)/2) * W/nf * 0.18u' pd='2*int((nf+1)/2) * (W/nf + 0.18u)' ps='2*int((nf+2)/2) * (W/nf + 0.18u)' nrd='0.18u / W' nrs='0.18u / W' sa=0 sb=0 sd=0
VO_m54 m54o Vmem 0
XR_m55 m55r m55r Vdd Vdd pfet_03v3 L=2.828u W=0.772u nf=1 ad='int((nf+1)/2) * W/nf * 0.18u' as='int((nf+2)/2) * W/nf * 0.18u' pd='2*int((nf+1)/2) * (W/nf + 0.18u)' ps='2*int((nf+2)/2) * (W/nf + 0.18u)' nrd='0.18u / W' nrs='0.18u / W' sa=0 sb=0 sd=0
VR_m55 nref m55r 0
XO_m55 m55o m55r Vdd Vdd pfet_03v3 L=4.965u W=2.487u nf=1 ad='int((nf+1)/2) * W/nf * 0.18u' as='int((nf+2)/2) * W/nf * 0.18u' pd='2*int((nf+1)/2) * (W/nf + 0.18u)' ps='2*int((nf+2)/2) * (W/nf + 0.18u)' nrd='0.18u / W' nrs='0.18u / W' sa=0 sb=0 sd=0
VO_m55 m55o Vmem 0
XR_m56 m56r m56r Vdd Vdd pfet_03v3 L=2.591u W=0.283u nf=1 ad='int((nf+1)/2) * W/nf * 0.18u' as='int((nf+2)/2) * W/nf * 0.18u' pd='2*int((nf+1)/2) * (W/nf + 0.18u)' ps='2*int((nf+2)/2) * (W/nf + 0.18u)' nrd='0.18u / W' nrs='0.18u / W' sa=0 sb=0 sd=0
VR_m56 nref m56r 0
XO_m56 m56o m56r Vdd Vdd pfet_03v3 L=7.156u W=3.222u nf=1 ad='int((nf+1)/2) * W/nf * 0.18u' as='int((nf+2)/2) * W/nf * 0.18u' pd='2*int((nf+1)/2) * (W/nf + 0.18u)' ps='2*int((nf+2)/2) * (W/nf + 0.18u)' nrd='0.18u / W' nrs='0.18u / W' sa=0 sb=0 sd=0
VO_m56 m56o Vmem 0
XR_m57 m57r m57r Vdd Vdd pfet_03v3 L=0.628u W=0.487u nf=1 ad='int((nf+1)/2) * W/nf * 0.18u' as='int((nf+2)/2) * W/nf * 0.18u' pd='2*int((nf+1)/2) * (W/nf + 0.18u)' ps='2*int((nf+2)/2) * (W/nf + 0.18u)' nrd='0.18u / W' nrs='0.18u / W' sa=0 sb=0 sd=0
VR_m57 nref m57r 0
XO_m57 m57o m57r Vdd Vdd pfet_03v3 L=0.341u W=1.806u nf=1 ad='int((nf+1)/2) * W/nf * 0.18u' as='int((nf+2)/2) * W/nf * 0.18u' pd='2*int((nf+1)/2) * (W/nf + 0.18u)' ps='2*int((nf+2)/2) * (W/nf + 0.18u)' nrd='0.18u / W' nrs='0.18u / W' sa=0 sb=0 sd=0
VO_m57 m57o Vmem 0
XR_m58 m58r m58r Vdd Vdd pfet_03v3 L=3.473u W=0.78u nf=1 ad='int((nf+1)/2) * W/nf * 0.18u' as='int((nf+2)/2) * W/nf * 0.18u' pd='2*int((nf+1)/2) * (W/nf + 0.18u)' ps='2*int((nf+2)/2) * (W/nf + 0.18u)' nrd='0.18u / W' nrs='0.18u / W' sa=0 sb=0 sd=0
VR_m58 nref m58r 0
XO_m58 m58o m58r Vdd Vdd pfet_03v3 L=2.139u W=2.153u nf=1 ad='int((nf+1)/2) * W/nf * 0.18u' as='int((nf+2)/2) * W/nf * 0.18u' pd='2*int((nf+1)/2) * (W/nf + 0.18u)' ps='2*int((nf+2)/2) * (W/nf + 0.18u)' nrd='0.18u / W' nrs='0.18u / W' sa=0 sb=0 sd=0
VO_m58 m58o Vmem 0
XR_m59 m59r m59r Vdd Vdd pfet_03v3 L=0.352u W=2.398u nf=1 ad='int((nf+1)/2) * W/nf * 0.18u' as='int((nf+2)/2) * W/nf * 0.18u' pd='2*int((nf+1)/2) * (W/nf + 0.18u)' ps='2*int((nf+2)/2) * (W/nf + 0.18u)' nrd='0.18u / W' nrs='0.18u / W' sa=0 sb=0 sd=0
VR_m59 nref m59r 0
XO_m59 m59o m59r Vdd Vdd pfet_03v3 L=1.071u W=0.625u nf=1 ad='int((nf+1)/2) * W/nf * 0.18u' as='int((nf+2)/2) * W/nf * 0.18u' pd='2*int((nf+1)/2) * (W/nf + 0.18u)' ps='2*int((nf+2)/2) * (W/nf + 0.18u)' nrd='0.18u / W' nrs='0.18u / W' sa=0 sb=0 sd=0
VO_m59 m59o Vmem 0
XR_m60 m60r m60r Vdd Vdd pfet_03v3 L=3.755u W=0.717u nf=1 ad='int((nf+1)/2) * W/nf * 0.18u' as='int((nf+2)/2) * W/nf * 0.18u' pd='2*int((nf+1)/2) * (W/nf + 0.18u)' ps='2*int((nf+2)/2) * (W/nf + 0.18u)' nrd='0.18u / W' nrs='0.18u / W' sa=0 sb=0 sd=0
VR_m60 nref m60r 0
XO_m60 m60o m60r Vdd Vdd pfet_03v3 L=2.869u W=1.615u nf=1 ad='int((nf+1)/2) * W/nf * 0.18u' as='int((nf+2)/2) * W/nf * 0.18u' pd='2*int((nf+1)/2) * (W/nf + 0.18u)' ps='2*int((nf+2)/2) * (W/nf + 0.18u)' nrd='0.18u / W' nrs='0.18u / W' sa=0 sb=0 sd=0
VO_m60 m60o Vmem 0
XR_m61 m61r m61r Vdd Vdd pfet_03v3 L=1.1u W=2.999u nf=1 ad='int((nf+1)/2) * W/nf * 0.18u' as='int((nf+2)/2) * W/nf * 0.18u' pd='2*int((nf+1)/2) * (W/nf + 0.18u)' ps='2*int((nf+2)/2) * (W/nf + 0.18u)' nrd='0.18u / W' nrs='0.18u / W' sa=0 sb=0 sd=0
VR_m61 nref m61r 0
XO_m61 m61o m61r Vdd Vdd pfet_03v3 L=5.138u W=0.463u nf=1 ad='int((nf+1)/2) * W/nf * 0.18u' as='int((nf+2)/2) * W/nf * 0.18u' pd='2*int((nf+1)/2) * (W/nf + 0.18u)' ps='2*int((nf+2)/2) * (W/nf + 0.18u)' nrd='0.18u / W' nrs='0.18u / W' sa=0 sb=0 sd=0
VO_m61 m61o Vmem 0
XR_m62 m62r m62r Vdd Vdd pfet_03v3 L=1.782u W=0.255u nf=1 ad='int((nf+1)/2) * W/nf * 0.18u' as='int((nf+2)/2) * W/nf * 0.18u' pd='2*int((nf+1)/2) * (W/nf + 0.18u)' ps='2*int((nf+2)/2) * (W/nf + 0.18u)' nrd='0.18u / W' nrs='0.18u / W' sa=0 sb=0 sd=0
VR_m62 nref m62r 0
XO_m62 m62o m62r Vdd Vdd pfet_03v3 L=1.415u W=0.564u nf=1 ad='int((nf+1)/2) * W/nf * 0.18u' as='int((nf+2)/2) * W/nf * 0.18u' pd='2*int((nf+1)/2) * (W/nf + 0.18u)' ps='2*int((nf+2)/2) * (W/nf + 0.18u)' nrd='0.18u / W' nrs='0.18u / W' sa=0 sb=0 sd=0
VO_m62 m62o Vmem 0
XR_m63 m63r m63r Vdd Vdd pfet_03v3 L=3.293u W=0.484u nf=1 ad='int((nf+1)/2) * W/nf * 0.18u' as='int((nf+2)/2) * W/nf * 0.18u' pd='2*int((nf+1)/2) * (W/nf + 0.18u)' ps='2*int((nf+2)/2) * (W/nf + 0.18u)' nrd='0.18u / W' nrs='0.18u / W' sa=0 sb=0 sd=0
VR_m63 nref m63r 0
XO_m63 m63o m63r Vdd Vdd pfet_03v3 L=3.638u W=0.258u nf=1 ad='int((nf+1)/2) * W/nf * 0.18u' as='int((nf+2)/2) * W/nf * 0.18u' pd='2*int((nf+1)/2) * (W/nf + 0.18u)' ps='2*int((nf+2)/2) * (W/nf + 0.18u)' nrd='0.18u / W' nrs='0.18u / W' sa=0 sb=0 sd=0
VO_m63 m63o Vmem 0
XR_m64 m64r m64r Vdd Vdd pfet_03v3 L=3.207u W=0.845u nf=1 ad='int((nf+1)/2) * W/nf * 0.18u' as='int((nf+2)/2) * W/nf * 0.18u' pd='2*int((nf+1)/2) * (W/nf + 0.18u)' ps='2*int((nf+2)/2) * (W/nf + 0.18u)' nrd='0.18u / W' nrs='0.18u / W' sa=0 sb=0 sd=0
VR_m64 nref m64r 0
XO_m64 m64o m64r Vdd Vdd pfet_03v3 L=3.396u W=0.311u nf=1 ad='int((nf+1)/2) * W/nf * 0.18u' as='int((nf+2)/2) * W/nf * 0.18u' pd='2*int((nf+1)/2) * (W/nf + 0.18u)' ps='2*int((nf+2)/2) * (W/nf + 0.18u)' nrd='0.18u / W' nrs='0.18u / W' sa=0 sb=0 sd=0
VO_m64 m64o Vmem 0
XR_m65 m65r m65r Vdd Vdd pfet_03v3 L=1.514u W=0.29u nf=1 ad='int((nf+1)/2) * W/nf * 0.18u' as='int((nf+2)/2) * W/nf * 0.18u' pd='2*int((nf+1)/2) * (W/nf + 0.18u)' ps='2*int((nf+2)/2) * (W/nf + 0.18u)' nrd='0.18u / W' nrs='0.18u / W' sa=0 sb=0 sd=0
VR_m65 nref m65r 0
XO_m65 m65o m65r Vdd Vdd pfet_03v3 L=1.051u W=1.052u nf=1 ad='int((nf+1)/2) * W/nf * 0.18u' as='int((nf+2)/2) * W/nf * 0.18u' pd='2*int((nf+1)/2) * (W/nf + 0.18u)' ps='2*int((nf+2)/2) * (W/nf + 0.18u)' nrd='0.18u / W' nrs='0.18u / W' sa=0 sb=0 sd=0
VO_m65 m65o Vmem 0
XR_m66 m66r m66r Vdd Vdd pfet_03v3 L=3.965u W=2.582u nf=1 ad='int((nf+1)/2) * W/nf * 0.18u' as='int((nf+2)/2) * W/nf * 0.18u' pd='2*int((nf+1)/2) * (W/nf + 0.18u)' ps='2*int((nf+2)/2) * (W/nf + 0.18u)' nrd='0.18u / W' nrs='0.18u / W' sa=0 sb=0 sd=0
VR_m66 nref m66r 0
XO_m66 m66o m66r Vdd Vdd pfet_03v3 L=1.572u W=1.489u nf=1 ad='int((nf+1)/2) * W/nf * 0.18u' as='int((nf+2)/2) * W/nf * 0.18u' pd='2*int((nf+1)/2) * (W/nf + 0.18u)' ps='2*int((nf+2)/2) * (W/nf + 0.18u)' nrd='0.18u / W' nrs='0.18u / W' sa=0 sb=0 sd=0
VO_m66 m66o Vmem 0
XR_m67 m67r m67r Vdd Vdd pfet_03v3 L=1.128u W=0.297u nf=1 ad='int((nf+1)/2) * W/nf * 0.18u' as='int((nf+2)/2) * W/nf * 0.18u' pd='2*int((nf+1)/2) * (W/nf + 0.18u)' ps='2*int((nf+2)/2) * (W/nf + 0.18u)' nrd='0.18u / W' nrs='0.18u / W' sa=0 sb=0 sd=0
VR_m67 nref m67r 0
XO_m67 m67o m67r Vdd Vdd pfet_03v3 L=2.317u W=0.432u nf=1 ad='int((nf+1)/2) * W/nf * 0.18u' as='int((nf+2)/2) * W/nf * 0.18u' pd='2*int((nf+1)/2) * (W/nf + 0.18u)' ps='2*int((nf+2)/2) * (W/nf + 0.18u)' nrd='0.18u / W' nrs='0.18u / W' sa=0 sb=0 sd=0
VO_m67 m67o Vmem 0
XR_m68 m68r m68r Vdd Vdd pfet_03v3 L=0.644u W=0.349u nf=1 ad='int((nf+1)/2) * W/nf * 0.18u' as='int((nf+2)/2) * W/nf * 0.18u' pd='2*int((nf+1)/2) * (W/nf + 0.18u)' ps='2*int((nf+2)/2) * (W/nf + 0.18u)' nrd='0.18u / W' nrs='0.18u / W' sa=0 sb=0 sd=0
VR_m68 nref m68r 0
XO_m68 m68o m68r Vdd Vdd pfet_03v3 L=6.064u W=0.549u nf=1 ad='int((nf+1)/2) * W/nf * 0.18u' as='int((nf+2)/2) * W/nf * 0.18u' pd='2*int((nf+1)/2) * (W/nf + 0.18u)' ps='2*int((nf+2)/2) * (W/nf + 0.18u)' nrd='0.18u / W' nrs='0.18u / W' sa=0 sb=0 sd=0
VO_m68 m68o Vmem 0
XR_m69 m69r m69r Vdd Vdd pfet_03v3 L=0.72u W=0.292u nf=1 ad='int((nf+1)/2) * W/nf * 0.18u' as='int((nf+2)/2) * W/nf * 0.18u' pd='2*int((nf+1)/2) * (W/nf + 0.18u)' ps='2*int((nf+2)/2) * (W/nf + 0.18u)' nrd='0.18u / W' nrs='0.18u / W' sa=0 sb=0 sd=0
VR_m69 nref m69r 0
XO_m69 m69o m69r Vdd Vdd pfet_03v3 L=0.393u W=1.419u nf=1 ad='int((nf+1)/2) * W/nf * 0.18u' as='int((nf+2)/2) * W/nf * 0.18u' pd='2*int((nf+1)/2) * (W/nf + 0.18u)' ps='2*int((nf+2)/2) * (W/nf + 0.18u)' nrd='0.18u / W' nrs='0.18u / W' sa=0 sb=0 sd=0
VO_m69 m69o Vmem 0
XR_m70 m70r m70r Vdd Vdd pfet_03v3 L=3.172u W=1.52u nf=1 ad='int((nf+1)/2) * W/nf * 0.18u' as='int((nf+2)/2) * W/nf * 0.18u' pd='2*int((nf+1)/2) * (W/nf + 0.18u)' ps='2*int((nf+2)/2) * (W/nf + 0.18u)' nrd='0.18u / W' nrs='0.18u / W' sa=0 sb=0 sd=0
VR_m70 nref m70r 0
XO_m70 m70o m70r Vdd Vdd pfet_03v3 L=3.192u W=3.369u nf=1 ad='int((nf+1)/2) * W/nf * 0.18u' as='int((nf+2)/2) * W/nf * 0.18u' pd='2*int((nf+1)/2) * (W/nf + 0.18u)' ps='2*int((nf+2)/2) * (W/nf + 0.18u)' nrd='0.18u / W' nrs='0.18u / W' sa=0 sb=0 sd=0
VO_m70 m70o Vmem 0
XR_m71 m71r m71r Vdd Vdd pfet_03v3 L=0.565u W=0.39u nf=1 ad='int((nf+1)/2) * W/nf * 0.18u' as='int((nf+2)/2) * W/nf * 0.18u' pd='2*int((nf+1)/2) * (W/nf + 0.18u)' ps='2*int((nf+2)/2) * (W/nf + 0.18u)' nrd='0.18u / W' nrs='0.18u / W' sa=0 sb=0 sd=0
VR_m71 nref m71r 0
XO_m71 m71o m71r Vdd Vdd pfet_03v3 L=2.189u W=0.383u nf=1 ad='int((nf+1)/2) * W/nf * 0.18u' as='int((nf+2)/2) * W/nf * 0.18u' pd='2*int((nf+1)/2) * (W/nf + 0.18u)' ps='2*int((nf+2)/2) * (W/nf + 0.18u)' nrd='0.18u / W' nrs='0.18u / W' sa=0 sb=0 sd=0
VO_m71 m71o Vmem 0
XR_m72 m72r m72r Vdd Vdd pfet_03v3 L=1.392u W=1.162u nf=1 ad='int((nf+1)/2) * W/nf * 0.18u' as='int((nf+2)/2) * W/nf * 0.18u' pd='2*int((nf+1)/2) * (W/nf + 0.18u)' ps='2*int((nf+2)/2) * (W/nf + 0.18u)' nrd='0.18u / W' nrs='0.18u / W' sa=0 sb=0 sd=0
VR_m72 nref m72r 0
XO_m72 m72o m72r Vdd Vdd pfet_03v3 L=5.792u W=2.667u nf=1 ad='int((nf+1)/2) * W/nf * 0.18u' as='int((nf+2)/2) * W/nf * 0.18u' pd='2*int((nf+1)/2) * (W/nf + 0.18u)' ps='2*int((nf+2)/2) * (W/nf + 0.18u)' nrd='0.18u / W' nrs='0.18u / W' sa=0 sb=0 sd=0
VO_m72 m72o Vmem 0
XR_m73 m73r m73r Vdd Vdd pfet_03v3 L=1.384u W=1.438u nf=1 ad='int((nf+1)/2) * W/nf * 0.18u' as='int((nf+2)/2) * W/nf * 0.18u' pd='2*int((nf+1)/2) * (W/nf + 0.18u)' ps='2*int((nf+2)/2) * (W/nf + 0.18u)' nrd='0.18u / W' nrs='0.18u / W' sa=0 sb=0 sd=0
VR_m73 nref m73r 0
XO_m73 m73o m73r Vdd Vdd pfet_03v3 L=0.305u W=0.967u nf=1 ad='int((nf+1)/2) * W/nf * 0.18u' as='int((nf+2)/2) * W/nf * 0.18u' pd='2*int((nf+1)/2) * (W/nf + 0.18u)' ps='2*int((nf+2)/2) * (W/nf + 0.18u)' nrd='0.18u / W' nrs='0.18u / W' sa=0 sb=0 sd=0
VO_m73 m73o Vmem 0
XR_m74 m74r m74r Vdd Vdd pfet_03v3 L=1.67u W=1.478u nf=1 ad='int((nf+1)/2) * W/nf * 0.18u' as='int((nf+2)/2) * W/nf * 0.18u' pd='2*int((nf+1)/2) * (W/nf + 0.18u)' ps='2*int((nf+2)/2) * (W/nf + 0.18u)' nrd='0.18u / W' nrs='0.18u / W' sa=0 sb=0 sd=0
VR_m74 nref m74r 0
XO_m74 m74o m74r Vdd Vdd pfet_03v3 L=3.24u W=0.457u nf=1 ad='int((nf+1)/2) * W/nf * 0.18u' as='int((nf+2)/2) * W/nf * 0.18u' pd='2*int((nf+1)/2) * (W/nf + 0.18u)' ps='2*int((nf+2)/2) * (W/nf + 0.18u)' nrd='0.18u / W' nrs='0.18u / W' sa=0 sb=0 sd=0
VO_m74 m74o Vmem 0
XR_m75 m75r m75r Vdd Vdd pfet_03v3 L=2.186u W=0.258u nf=1 ad='int((nf+1)/2) * W/nf * 0.18u' as='int((nf+2)/2) * W/nf * 0.18u' pd='2*int((nf+1)/2) * (W/nf + 0.18u)' ps='2*int((nf+2)/2) * (W/nf + 0.18u)' nrd='0.18u / W' nrs='0.18u / W' sa=0 sb=0 sd=0
VR_m75 nref m75r 0
XO_m75 m75o m75r Vdd Vdd pfet_03v3 L=4.356u W=1.781u nf=1 ad='int((nf+1)/2) * W/nf * 0.18u' as='int((nf+2)/2) * W/nf * 0.18u' pd='2*int((nf+1)/2) * (W/nf + 0.18u)' ps='2*int((nf+2)/2) * (W/nf + 0.18u)' nrd='0.18u / W' nrs='0.18u / W' sa=0 sb=0 sd=0
VO_m75 m75o Vmem 0
XR_m76 m76r m76r Vdd Vdd pfet_03v3 L=1.001u W=1.956u nf=1 ad='int((nf+1)/2) * W/nf * 0.18u' as='int((nf+2)/2) * W/nf * 0.18u' pd='2*int((nf+1)/2) * (W/nf + 0.18u)' ps='2*int((nf+2)/2) * (W/nf + 0.18u)' nrd='0.18u / W' nrs='0.18u / W' sa=0 sb=0 sd=0
VR_m76 nref m76r 0
XO_m76 m76o m76r Vdd Vdd pfet_03v3 L=0.472u W=0.491u nf=1 ad='int((nf+1)/2) * W/nf * 0.18u' as='int((nf+2)/2) * W/nf * 0.18u' pd='2*int((nf+1)/2) * (W/nf + 0.18u)' ps='2*int((nf+2)/2) * (W/nf + 0.18u)' nrd='0.18u / W' nrs='0.18u / W' sa=0 sb=0 sd=0
VO_m76 m76o Vmem 0
XR_m77 m77r m77r Vdd Vdd pfet_03v3 L=3.852u W=0.447u nf=1 ad='int((nf+1)/2) * W/nf * 0.18u' as='int((nf+2)/2) * W/nf * 0.18u' pd='2*int((nf+1)/2) * (W/nf + 0.18u)' ps='2*int((nf+2)/2) * (W/nf + 0.18u)' nrd='0.18u / W' nrs='0.18u / W' sa=0 sb=0 sd=0
VR_m77 nref m77r 0
XO_m77 m77o m77r Vdd Vdd pfet_03v3 L=1.865u W=2.295u nf=1 ad='int((nf+1)/2) * W/nf * 0.18u' as='int((nf+2)/2) * W/nf * 0.18u' pd='2*int((nf+1)/2) * (W/nf + 0.18u)' ps='2*int((nf+2)/2) * (W/nf + 0.18u)' nrd='0.18u / W' nrs='0.18u / W' sa=0 sb=0 sd=0
VO_m77 m77o Vmem 0
XR_m78 m78r m78r Vdd Vdd pfet_03v3 L=2.52u W=0.287u nf=1 ad='int((nf+1)/2) * W/nf * 0.18u' as='int((nf+2)/2) * W/nf * 0.18u' pd='2*int((nf+1)/2) * (W/nf + 0.18u)' ps='2*int((nf+2)/2) * (W/nf + 0.18u)' nrd='0.18u / W' nrs='0.18u / W' sa=0 sb=0 sd=0
VR_m78 nref m78r 0
XO_m78 m78o m78r Vdd Vdd pfet_03v3 L=2.774u W=0.377u nf=1 ad='int((nf+1)/2) * W/nf * 0.18u' as='int((nf+2)/2) * W/nf * 0.18u' pd='2*int((nf+1)/2) * (W/nf + 0.18u)' ps='2*int((nf+2)/2) * (W/nf + 0.18u)' nrd='0.18u / W' nrs='0.18u / W' sa=0 sb=0 sd=0
VO_m78 m78o Vmem 0
XR_m79 m79r m79r Vdd Vdd pfet_03v3 L=0.619u W=0.907u nf=1 ad='int((nf+1)/2) * W/nf * 0.18u' as='int((nf+2)/2) * W/nf * 0.18u' pd='2*int((nf+1)/2) * (W/nf + 0.18u)' ps='2*int((nf+2)/2) * (W/nf + 0.18u)' nrd='0.18u / W' nrs='0.18u / W' sa=0 sb=0 sd=0
VR_m79 nref m79r 0
XO_m79 m79o m79r Vdd Vdd pfet_03v3 L=4.705u W=0.673u nf=1 ad='int((nf+1)/2) * W/nf * 0.18u' as='int((nf+2)/2) * W/nf * 0.18u' pd='2*int((nf+1)/2) * (W/nf + 0.18u)' ps='2*int((nf+2)/2) * (W/nf + 0.18u)' nrd='0.18u / W' nrs='0.18u / W' sa=0 sb=0 sd=0
VO_m79 m79o Vmem 0
XR_m80 m80r m80r Vdd Vdd pfet_03v3 L=2.108u W=0.297u nf=1 ad='int((nf+1)/2) * W/nf * 0.18u' as='int((nf+2)/2) * W/nf * 0.18u' pd='2*int((nf+1)/2) * (W/nf + 0.18u)' ps='2*int((nf+2)/2) * (W/nf + 0.18u)' nrd='0.18u / W' nrs='0.18u / W' sa=0 sb=0 sd=0
VR_m80 nref m80r 0
XO_m80 m80o m80r Vdd Vdd pfet_03v3 L=0.639u W=1.965u nf=1 ad='int((nf+1)/2) * W/nf * 0.18u' as='int((nf+2)/2) * W/nf * 0.18u' pd='2*int((nf+1)/2) * (W/nf + 0.18u)' ps='2*int((nf+2)/2) * (W/nf + 0.18u)' nrd='0.18u / W' nrs='0.18u / W' sa=0 sb=0 sd=0
VO_m80 m80o Vmem 0
XR_m81 m81r m81r Vdd Vdd pfet_03v3 L=0.617u W=3.45u nf=1 ad='int((nf+1)/2) * W/nf * 0.18u' as='int((nf+2)/2) * W/nf * 0.18u' pd='2*int((nf+1)/2) * (W/nf + 0.18u)' ps='2*int((nf+2)/2) * (W/nf + 0.18u)' nrd='0.18u / W' nrs='0.18u / W' sa=0 sb=0 sd=0
VR_m81 nref m81r 0
XO_m81 m81o m81r Vdd Vdd pfet_03v3 L=0.697u W=0.452u nf=1 ad='int((nf+1)/2) * W/nf * 0.18u' as='int((nf+2)/2) * W/nf * 0.18u' pd='2*int((nf+1)/2) * (W/nf + 0.18u)' ps='2*int((nf+2)/2) * (W/nf + 0.18u)' nrd='0.18u / W' nrs='0.18u / W' sa=0 sb=0 sd=0
VO_m81 m81o Vmem 0
XR_m82 m82r m82r Vdd Vdd pfet_03v3 L=1.476u W=0.739u nf=1 ad='int((nf+1)/2) * W/nf * 0.18u' as='int((nf+2)/2) * W/nf * 0.18u' pd='2*int((nf+1)/2) * (W/nf + 0.18u)' ps='2*int((nf+2)/2) * (W/nf + 0.18u)' nrd='0.18u / W' nrs='0.18u / W' sa=0 sb=0 sd=0
VR_m82 nref m82r 0
XO_m82 m82o m82r Vdd Vdd pfet_03v3 L=0.676u W=1.204u nf=1 ad='int((nf+1)/2) * W/nf * 0.18u' as='int((nf+2)/2) * W/nf * 0.18u' pd='2*int((nf+1)/2) * (W/nf + 0.18u)' ps='2*int((nf+2)/2) * (W/nf + 0.18u)' nrd='0.18u / W' nrs='0.18u / W' sa=0 sb=0 sd=0
VO_m82 m82o Vmem 0
XR_m83 m83r m83r Vdd Vdd pfet_03v3 L=2.668u W=1.654u nf=1 ad='int((nf+1)/2) * W/nf * 0.18u' as='int((nf+2)/2) * W/nf * 0.18u' pd='2*int((nf+1)/2) * (W/nf + 0.18u)' ps='2*int((nf+2)/2) * (W/nf + 0.18u)' nrd='0.18u / W' nrs='0.18u / W' sa=0 sb=0 sd=0
VR_m83 nref m83r 0
XO_m83 m83o m83r Vdd Vdd pfet_03v3 L=1.196u W=3.846u nf=1 ad='int((nf+1)/2) * W/nf * 0.18u' as='int((nf+2)/2) * W/nf * 0.18u' pd='2*int((nf+1)/2) * (W/nf + 0.18u)' ps='2*int((nf+2)/2) * (W/nf + 0.18u)' nrd='0.18u / W' nrs='0.18u / W' sa=0 sb=0 sd=0
VO_m83 m83o Vmem 0
XR_m84 m84r m84r Vdd Vdd pfet_03v3 L=0.402u W=2.511u nf=1 ad='int((nf+1)/2) * W/nf * 0.18u' as='int((nf+2)/2) * W/nf * 0.18u' pd='2*int((nf+1)/2) * (W/nf + 0.18u)' ps='2*int((nf+2)/2) * (W/nf + 0.18u)' nrd='0.18u / W' nrs='0.18u / W' sa=0 sb=0 sd=0
VR_m84 nref m84r 0
XO_m84 m84o m84r Vdd Vdd pfet_03v3 L=2.704u W=0.436u nf=1 ad='int((nf+1)/2) * W/nf * 0.18u' as='int((nf+2)/2) * W/nf * 0.18u' pd='2*int((nf+1)/2) * (W/nf + 0.18u)' ps='2*int((nf+2)/2) * (W/nf + 0.18u)' nrd='0.18u / W' nrs='0.18u / W' sa=0 sb=0 sd=0
VO_m84 m84o Vmem 0
XR_m85 m85r m85r Vdd Vdd pfet_03v3 L=2.126u W=0.889u nf=1 ad='int((nf+1)/2) * W/nf * 0.18u' as='int((nf+2)/2) * W/nf * 0.18u' pd='2*int((nf+1)/2) * (W/nf + 0.18u)' ps='2*int((nf+2)/2) * (W/nf + 0.18u)' nrd='0.18u / W' nrs='0.18u / W' sa=0 sb=0 sd=0
VR_m85 nref m85r 0
XO_m85 m85o m85r Vdd Vdd pfet_03v3 L=0.714u W=3.631u nf=1 ad='int((nf+1)/2) * W/nf * 0.18u' as='int((nf+2)/2) * W/nf * 0.18u' pd='2*int((nf+1)/2) * (W/nf + 0.18u)' ps='2*int((nf+2)/2) * (W/nf + 0.18u)' nrd='0.18u / W' nrs='0.18u / W' sa=0 sb=0 sd=0
VO_m85 m85o Vmem 0
XR_m86 m86r m86r Vdd Vdd pfet_03v3 L=0.534u W=0.569u nf=1 ad='int((nf+1)/2) * W/nf * 0.18u' as='int((nf+2)/2) * W/nf * 0.18u' pd='2*int((nf+1)/2) * (W/nf + 0.18u)' ps='2*int((nf+2)/2) * (W/nf + 0.18u)' nrd='0.18u / W' nrs='0.18u / W' sa=0 sb=0 sd=0
VR_m86 nref m86r 0
XO_m86 m86o m86r Vdd Vdd pfet_03v3 L=4.391u W=1.984u nf=1 ad='int((nf+1)/2) * W/nf * 0.18u' as='int((nf+2)/2) * W/nf * 0.18u' pd='2*int((nf+1)/2) * (W/nf + 0.18u)' ps='2*int((nf+2)/2) * (W/nf + 0.18u)' nrd='0.18u / W' nrs='0.18u / W' sa=0 sb=0 sd=0
VO_m86 m86o Vmem 0
XR_m87 m87r m87r Vdd Vdd pfet_03v3 L=0.457u W=1.076u nf=1 ad='int((nf+1)/2) * W/nf * 0.18u' as='int((nf+2)/2) * W/nf * 0.18u' pd='2*int((nf+1)/2) * (W/nf + 0.18u)' ps='2*int((nf+2)/2) * (W/nf + 0.18u)' nrd='0.18u / W' nrs='0.18u / W' sa=0 sb=0 sd=0
VR_m87 nref m87r 0
XO_m87 m87o m87r Vdd Vdd pfet_03v3 L=1.681u W=1.313u nf=1 ad='int((nf+1)/2) * W/nf * 0.18u' as='int((nf+2)/2) * W/nf * 0.18u' pd='2*int((nf+1)/2) * (W/nf + 0.18u)' ps='2*int((nf+2)/2) * (W/nf + 0.18u)' nrd='0.18u / W' nrs='0.18u / W' sa=0 sb=0 sd=0
VO_m87 m87o Vmem 0
XR_m88 m88r m88r Vdd Vdd pfet_03v3 L=2.919u W=1.705u nf=1 ad='int((nf+1)/2) * W/nf * 0.18u' as='int((nf+2)/2) * W/nf * 0.18u' pd='2*int((nf+1)/2) * (W/nf + 0.18u)' ps='2*int((nf+2)/2) * (W/nf + 0.18u)' nrd='0.18u / W' nrs='0.18u / W' sa=0 sb=0 sd=0
VR_m88 nref m88r 0
XO_m88 m88o m88r Vdd Vdd pfet_03v3 L=0.321u W=0.308u nf=1 ad='int((nf+1)/2) * W/nf * 0.18u' as='int((nf+2)/2) * W/nf * 0.18u' pd='2*int((nf+1)/2) * (W/nf + 0.18u)' ps='2*int((nf+2)/2) * (W/nf + 0.18u)' nrd='0.18u / W' nrs='0.18u / W' sa=0 sb=0 sd=0
VO_m88 m88o Vmem 0
XR_m89 m89r m89r Vdd Vdd pfet_03v3 L=0.747u W=3.587u nf=1 ad='int((nf+1)/2) * W/nf * 0.18u' as='int((nf+2)/2) * W/nf * 0.18u' pd='2*int((nf+1)/2) * (W/nf + 0.18u)' ps='2*int((nf+2)/2) * (W/nf + 0.18u)' nrd='0.18u / W' nrs='0.18u / W' sa=0 sb=0 sd=0
VR_m89 nref m89r 0
XO_m89 m89o m89r Vdd Vdd pfet_03v3 L=2.103u W=2.578u nf=1 ad='int((nf+1)/2) * W/nf * 0.18u' as='int((nf+2)/2) * W/nf * 0.18u' pd='2*int((nf+1)/2) * (W/nf + 0.18u)' ps='2*int((nf+2)/2) * (W/nf + 0.18u)' nrd='0.18u / W' nrs='0.18u / W' sa=0 sb=0 sd=0
VO_m89 m89o Vmem 0
XR_m90 m90r m90r Vdd Vdd pfet_03v3 L=2.146u W=0.737u nf=1 ad='int((nf+1)/2) * W/nf * 0.18u' as='int((nf+2)/2) * W/nf * 0.18u' pd='2*int((nf+1)/2) * (W/nf + 0.18u)' ps='2*int((nf+2)/2) * (W/nf + 0.18u)' nrd='0.18u / W' nrs='0.18u / W' sa=0 sb=0 sd=0
VR_m90 nref m90r 0
XO_m90 m90o m90r Vdd Vdd pfet_03v3 L=7.74u W=3.031u nf=1 ad='int((nf+1)/2) * W/nf * 0.18u' as='int((nf+2)/2) * W/nf * 0.18u' pd='2*int((nf+1)/2) * (W/nf + 0.18u)' ps='2*int((nf+2)/2) * (W/nf + 0.18u)' nrd='0.18u / W' nrs='0.18u / W' sa=0 sb=0 sd=0
VO_m90 m90o Vmem 0
XR_m91 m91r m91r Vdd Vdd pfet_03v3 L=1.835u W=1.315u nf=1 ad='int((nf+1)/2) * W/nf * 0.18u' as='int((nf+2)/2) * W/nf * 0.18u' pd='2*int((nf+1)/2) * (W/nf + 0.18u)' ps='2*int((nf+2)/2) * (W/nf + 0.18u)' nrd='0.18u / W' nrs='0.18u / W' sa=0 sb=0 sd=0
VR_m91 nref m91r 0
XO_m91 m91o m91r Vdd Vdd pfet_03v3 L=2.868u W=0.423u nf=1 ad='int((nf+1)/2) * W/nf * 0.18u' as='int((nf+2)/2) * W/nf * 0.18u' pd='2*int((nf+1)/2) * (W/nf + 0.18u)' ps='2*int((nf+2)/2) * (W/nf + 0.18u)' nrd='0.18u / W' nrs='0.18u / W' sa=0 sb=0 sd=0
VO_m91 m91o Vmem 0
XR_m92 m92r m92r Vdd Vdd pfet_03v3 L=1.655u W=1.546u nf=1 ad='int((nf+1)/2) * W/nf * 0.18u' as='int((nf+2)/2) * W/nf * 0.18u' pd='2*int((nf+1)/2) * (W/nf + 0.18u)' ps='2*int((nf+2)/2) * (W/nf + 0.18u)' nrd='0.18u / W' nrs='0.18u / W' sa=0 sb=0 sd=0
VR_m92 nref m92r 0
XO_m92 m92o m92r Vdd Vdd pfet_03v3 L=1.763u W=2.66u nf=1 ad='int((nf+1)/2) * W/nf * 0.18u' as='int((nf+2)/2) * W/nf * 0.18u' pd='2*int((nf+1)/2) * (W/nf + 0.18u)' ps='2*int((nf+2)/2) * (W/nf + 0.18u)' nrd='0.18u / W' nrs='0.18u / W' sa=0 sb=0 sd=0
VO_m92 m92o Vmem 0
XR_m93 m93r m93r Vdd Vdd pfet_03v3 L=1.235u W=0.327u nf=1 ad='int((nf+1)/2) * W/nf * 0.18u' as='int((nf+2)/2) * W/nf * 0.18u' pd='2*int((nf+1)/2) * (W/nf + 0.18u)' ps='2*int((nf+2)/2) * (W/nf + 0.18u)' nrd='0.18u / W' nrs='0.18u / W' sa=0 sb=0 sd=0
VR_m93 nref m93r 0
XO_m93 m93o m93r Vdd Vdd pfet_03v3 L=0.849u W=0.842u nf=1 ad='int((nf+1)/2) * W/nf * 0.18u' as='int((nf+2)/2) * W/nf * 0.18u' pd='2*int((nf+1)/2) * (W/nf + 0.18u)' ps='2*int((nf+2)/2) * (W/nf + 0.18u)' nrd='0.18u / W' nrs='0.18u / W' sa=0 sb=0 sd=0
VO_m93 m93o Vmem 0
XR_m94 m94r m94r Vdd Vdd pfet_03v3 L=1.506u W=2.043u nf=1 ad='int((nf+1)/2) * W/nf * 0.18u' as='int((nf+2)/2) * W/nf * 0.18u' pd='2*int((nf+1)/2) * (W/nf + 0.18u)' ps='2*int((nf+2)/2) * (W/nf + 0.18u)' nrd='0.18u / W' nrs='0.18u / W' sa=0 sb=0 sd=0
VR_m94 nref m94r 0
XO_m94 m94o m94r Vdd Vdd pfet_03v3 L=2.202u W=1.839u nf=1 ad='int((nf+1)/2) * W/nf * 0.18u' as='int((nf+2)/2) * W/nf * 0.18u' pd='2*int((nf+1)/2) * (W/nf + 0.18u)' ps='2*int((nf+2)/2) * (W/nf + 0.18u)' nrd='0.18u / W' nrs='0.18u / W' sa=0 sb=0 sd=0
VO_m94 m94o Vmem 0
XR_m95 m95r m95r Vdd Vdd pfet_03v3 L=0.587u W=0.479u nf=1 ad='int((nf+1)/2) * W/nf * 0.18u' as='int((nf+2)/2) * W/nf * 0.18u' pd='2*int((nf+1)/2) * (W/nf + 0.18u)' ps='2*int((nf+2)/2) * (W/nf + 0.18u)' nrd='0.18u / W' nrs='0.18u / W' sa=0 sb=0 sd=0
VR_m95 nref m95r 0
XO_m95 m95o m95r Vdd Vdd pfet_03v3 L=3.297u W=0.633u nf=1 ad='int((nf+1)/2) * W/nf * 0.18u' as='int((nf+2)/2) * W/nf * 0.18u' pd='2*int((nf+1)/2) * (W/nf + 0.18u)' ps='2*int((nf+2)/2) * (W/nf + 0.18u)' nrd='0.18u / W' nrs='0.18u / W' sa=0 sb=0 sd=0
VO_m95 m95o Vmem 0
XR_m96 m96r m96r Vdd Vdd pfet_03v3 L=2.144u W=0.442u nf=1 ad='int((nf+1)/2) * W/nf * 0.18u' as='int((nf+2)/2) * W/nf * 0.18u' pd='2*int((nf+1)/2) * (W/nf + 0.18u)' ps='2*int((nf+2)/2) * (W/nf + 0.18u)' nrd='0.18u / W' nrs='0.18u / W' sa=0 sb=0 sd=0
VR_m96 nref m96r 0
XO_m96 m96o m96r Vdd Vdd pfet_03v3 L=0.623u W=1.319u nf=1 ad='int((nf+1)/2) * W/nf * 0.18u' as='int((nf+2)/2) * W/nf * 0.18u' pd='2*int((nf+1)/2) * (W/nf + 0.18u)' ps='2*int((nf+2)/2) * (W/nf + 0.18u)' nrd='0.18u / W' nrs='0.18u / W' sa=0 sb=0 sd=0
VO_m96 m96o Vmem 0
XR_m97 m97r m97r Vdd Vdd pfet_03v3 L=2.36u W=1.454u nf=1 ad='int((nf+1)/2) * W/nf * 0.18u' as='int((nf+2)/2) * W/nf * 0.18u' pd='2*int((nf+1)/2) * (W/nf + 0.18u)' ps='2*int((nf+2)/2) * (W/nf + 0.18u)' nrd='0.18u / W' nrs='0.18u / W' sa=0 sb=0 sd=0
VR_m97 nref m97r 0
XO_m97 m97o m97r Vdd Vdd pfet_03v3 L=4.22u W=1.598u nf=1 ad='int((nf+1)/2) * W/nf * 0.18u' as='int((nf+2)/2) * W/nf * 0.18u' pd='2*int((nf+1)/2) * (W/nf + 0.18u)' ps='2*int((nf+2)/2) * (W/nf + 0.18u)' nrd='0.18u / W' nrs='0.18u / W' sa=0 sb=0 sd=0
VO_m97 m97o Vmem 0
XR_m98 m98r m98r Vdd Vdd pfet_03v3 L=0.389u W=1.861u nf=1 ad='int((nf+1)/2) * W/nf * 0.18u' as='int((nf+2)/2) * W/nf * 0.18u' pd='2*int((nf+1)/2) * (W/nf + 0.18u)' ps='2*int((nf+2)/2) * (W/nf + 0.18u)' nrd='0.18u / W' nrs='0.18u / W' sa=0 sb=0 sd=0
VR_m98 nref m98r 0
XO_m98 m98o m98r Vdd Vdd pfet_03v3 L=2.207u W=0.819u nf=1 ad='int((nf+1)/2) * W/nf * 0.18u' as='int((nf+2)/2) * W/nf * 0.18u' pd='2*int((nf+1)/2) * (W/nf + 0.18u)' ps='2*int((nf+2)/2) * (W/nf + 0.18u)' nrd='0.18u / W' nrs='0.18u / W' sa=0 sb=0 sd=0
VO_m98 m98o Vmem 0
XR_m99 m99r m99r Vdd Vdd pfet_03v3 L=0.473u W=0.787u nf=1 ad='int((nf+1)/2) * W/nf * 0.18u' as='int((nf+2)/2) * W/nf * 0.18u' pd='2*int((nf+1)/2) * (W/nf + 0.18u)' ps='2*int((nf+2)/2) * (W/nf + 0.18u)' nrd='0.18u / W' nrs='0.18u / W' sa=0 sb=0 sd=0
VR_m99 nref m99r 0
XO_m99 m99o m99r Vdd Vdd pfet_03v3 L=3.911u W=1.997u nf=1 ad='int((nf+1)/2) * W/nf * 0.18u' as='int((nf+2)/2) * W/nf * 0.18u' pd='2*int((nf+1)/2) * (W/nf + 0.18u)' ps='2*int((nf+2)/2) * (W/nf + 0.18u)' nrd='0.18u / W' nrs='0.18u / W' sa=0 sb=0 sd=0
VO_m99 m99o Vmem 0
XR_m100 m100r m100r Vdd Vdd pfet_03v3 L=1.515u W=0.385u nf=1 ad='int((nf+1)/2) * W/nf * 0.18u' as='int((nf+2)/2) * W/nf * 0.18u' pd='2*int((nf+1)/2) * (W/nf + 0.18u)' ps='2*int((nf+2)/2) * (W/nf + 0.18u)' nrd='0.18u / W' nrs='0.18u / W' sa=0 sb=0 sd=0
VR_m100 nref m100r 0
XO_m100 m100o m100r Vdd Vdd pfet_03v3 L=0.886u W=1.576u nf=1 ad='int((nf+1)/2) * W/nf * 0.18u' as='int((nf+2)/2) * W/nf * 0.18u' pd='2*int((nf+1)/2) * (W/nf + 0.18u)' ps='2*int((nf+2)/2) * (W/nf + 0.18u)' nrd='0.18u / W' nrs='0.18u / W' sa=0 sb=0 sd=0
VO_m100 m100o Vmem 0
XR_m101 m101r m101r Vdd Vdd pfet_03v3 L=0.617u W=1.621u nf=1 ad='int((nf+1)/2) * W/nf * 0.18u' as='int((nf+2)/2) * W/nf * 0.18u' pd='2*int((nf+1)/2) * (W/nf + 0.18u)' ps='2*int((nf+2)/2) * (W/nf + 0.18u)' nrd='0.18u / W' nrs='0.18u / W' sa=0 sb=0 sd=0
VR_m101 nref m101r 0
XO_m101 m101o m101r Vdd Vdd pfet_03v3 L=0.724u W=0.329u nf=1 ad='int((nf+1)/2) * W/nf * 0.18u' as='int((nf+2)/2) * W/nf * 0.18u' pd='2*int((nf+1)/2) * (W/nf + 0.18u)' ps='2*int((nf+2)/2) * (W/nf + 0.18u)' nrd='0.18u / W' nrs='0.18u / W' sa=0 sb=0 sd=0
VO_m101 m101o Vmem 0
XR_m102 m102r m102r Vdd Vdd pfet_03v3 L=0.717u W=0.249u nf=1 ad='int((nf+1)/2) * W/nf * 0.18u' as='int((nf+2)/2) * W/nf * 0.18u' pd='2*int((nf+1)/2) * (W/nf + 0.18u)' ps='2*int((nf+2)/2) * (W/nf + 0.18u)' nrd='0.18u / W' nrs='0.18u / W' sa=0 sb=0 sd=0
VR_m102 nref m102r 0
XO_m102 m102o m102r Vdd Vdd pfet_03v3 L=0.678u W=0.978u nf=1 ad='int((nf+1)/2) * W/nf * 0.18u' as='int((nf+2)/2) * W/nf * 0.18u' pd='2*int((nf+1)/2) * (W/nf + 0.18u)' ps='2*int((nf+2)/2) * (W/nf + 0.18u)' nrd='0.18u / W' nrs='0.18u / W' sa=0 sb=0 sd=0
VO_m102 m102o Vmem 0
XR_m103 m103r m103r Vdd Vdd pfet_03v3 L=3.373u W=1.789u nf=1 ad='int((nf+1)/2) * W/nf * 0.18u' as='int((nf+2)/2) * W/nf * 0.18u' pd='2*int((nf+1)/2) * (W/nf + 0.18u)' ps='2*int((nf+2)/2) * (W/nf + 0.18u)' nrd='0.18u / W' nrs='0.18u / W' sa=0 sb=0 sd=0
VR_m103 nref m103r 0
XO_m103 m103o m103r Vdd Vdd pfet_03v3 L=0.62u W=2.466u nf=1 ad='int((nf+1)/2) * W/nf * 0.18u' as='int((nf+2)/2) * W/nf * 0.18u' pd='2*int((nf+1)/2) * (W/nf + 0.18u)' ps='2*int((nf+2)/2) * (W/nf + 0.18u)' nrd='0.18u / W' nrs='0.18u / W' sa=0 sb=0 sd=0
VO_m103 m103o Vmem 0
XR_m104 m104r m104r Vdd Vdd pfet_03v3 L=0.409u W=1.09u nf=1 ad='int((nf+1)/2) * W/nf * 0.18u' as='int((nf+2)/2) * W/nf * 0.18u' pd='2*int((nf+1)/2) * (W/nf + 0.18u)' ps='2*int((nf+2)/2) * (W/nf + 0.18u)' nrd='0.18u / W' nrs='0.18u / W' sa=0 sb=0 sd=0
VR_m104 nref m104r 0
XO_m104 m104o m104r Vdd Vdd pfet_03v3 L=4.167u W=2.286u nf=1 ad='int((nf+1)/2) * W/nf * 0.18u' as='int((nf+2)/2) * W/nf * 0.18u' pd='2*int((nf+1)/2) * (W/nf + 0.18u)' ps='2*int((nf+2)/2) * (W/nf + 0.18u)' nrd='0.18u / W' nrs='0.18u / W' sa=0 sb=0 sd=0
VO_m104 m104o Vmem 0
XR_m105 m105r m105r Vdd Vdd pfet_03v3 L=1.146u W=2.873u nf=1 ad='int((nf+1)/2) * W/nf * 0.18u' as='int((nf+2)/2) * W/nf * 0.18u' pd='2*int((nf+1)/2) * (W/nf + 0.18u)' ps='2*int((nf+2)/2) * (W/nf + 0.18u)' nrd='0.18u / W' nrs='0.18u / W' sa=0 sb=0 sd=0
VR_m105 nref m105r 0
XO_m105 m105o m105r Vdd Vdd pfet_03v3 L=3.043u W=2.891u nf=1 ad='int((nf+1)/2) * W/nf * 0.18u' as='int((nf+2)/2) * W/nf * 0.18u' pd='2*int((nf+1)/2) * (W/nf + 0.18u)' ps='2*int((nf+2)/2) * (W/nf + 0.18u)' nrd='0.18u / W' nrs='0.18u / W' sa=0 sb=0 sd=0
VO_m105 m105o Vmem 0
XR_m106 m106r m106r Vdd Vdd pfet_03v3 L=0.608u W=1.519u nf=1 ad='int((nf+1)/2) * W/nf * 0.18u' as='int((nf+2)/2) * W/nf * 0.18u' pd='2*int((nf+1)/2) * (W/nf + 0.18u)' ps='2*int((nf+2)/2) * (W/nf + 0.18u)' nrd='0.18u / W' nrs='0.18u / W' sa=0 sb=0 sd=0
VR_m106 nref m106r 0
XO_m106 m106o m106r Vdd Vdd pfet_03v3 L=4.315u W=0.234u nf=1 ad='int((nf+1)/2) * W/nf * 0.18u' as='int((nf+2)/2) * W/nf * 0.18u' pd='2*int((nf+1)/2) * (W/nf + 0.18u)' ps='2*int((nf+2)/2) * (W/nf + 0.18u)' nrd='0.18u / W' nrs='0.18u / W' sa=0 sb=0 sd=0
VO_m106 m106o Vmem 0
XR_m107 m107r m107r Vdd Vdd pfet_03v3 L=2.372u W=1.889u nf=1 ad='int((nf+1)/2) * W/nf * 0.18u' as='int((nf+2)/2) * W/nf * 0.18u' pd='2*int((nf+1)/2) * (W/nf + 0.18u)' ps='2*int((nf+2)/2) * (W/nf + 0.18u)' nrd='0.18u / W' nrs='0.18u / W' sa=0 sb=0 sd=0
VR_m107 nref m107r 0
XO_m107 m107o m107r Vdd Vdd pfet_03v3 L=3.981u W=3.177u nf=1 ad='int((nf+1)/2) * W/nf * 0.18u' as='int((nf+2)/2) * W/nf * 0.18u' pd='2*int((nf+1)/2) * (W/nf + 0.18u)' ps='2*int((nf+2)/2) * (W/nf + 0.18u)' nrd='0.18u / W' nrs='0.18u / W' sa=0 sb=0 sd=0
VO_m107 m107o Vmem 0
XR_m108 m108r m108r Vdd Vdd pfet_03v3 L=2.836u W=0.579u nf=1 ad='int((nf+1)/2) * W/nf * 0.18u' as='int((nf+2)/2) * W/nf * 0.18u' pd='2*int((nf+1)/2) * (W/nf + 0.18u)' ps='2*int((nf+2)/2) * (W/nf + 0.18u)' nrd='0.18u / W' nrs='0.18u / W' sa=0 sb=0 sd=0
VR_m108 nref m108r 0
XO_m108 m108o m108r Vdd Vdd pfet_03v3 L=1.868u W=1.977u nf=1 ad='int((nf+1)/2) * W/nf * 0.18u' as='int((nf+2)/2) * W/nf * 0.18u' pd='2*int((nf+1)/2) * (W/nf + 0.18u)' ps='2*int((nf+2)/2) * (W/nf + 0.18u)' nrd='0.18u / W' nrs='0.18u / W' sa=0 sb=0 sd=0
VO_m108 m108o Vmem 0
XR_m109 m109r m109r Vdd Vdd pfet_03v3 L=3.624u W=0.535u nf=1 ad='int((nf+1)/2) * W/nf * 0.18u' as='int((nf+2)/2) * W/nf * 0.18u' pd='2*int((nf+1)/2) * (W/nf + 0.18u)' ps='2*int((nf+2)/2) * (W/nf + 0.18u)' nrd='0.18u / W' nrs='0.18u / W' sa=0 sb=0 sd=0
VR_m109 nref m109r 0
XO_m109 m109o m109r Vdd Vdd pfet_03v3 L=0.908u W=0.318u nf=1 ad='int((nf+1)/2) * W/nf * 0.18u' as='int((nf+2)/2) * W/nf * 0.18u' pd='2*int((nf+1)/2) * (W/nf + 0.18u)' ps='2*int((nf+2)/2) * (W/nf + 0.18u)' nrd='0.18u / W' nrs='0.18u / W' sa=0 sb=0 sd=0
VO_m109 m109o Vmem 0
XR_m110 m110r m110r Vdd Vdd pfet_03v3 L=1.399u W=0.604u nf=1 ad='int((nf+1)/2) * W/nf * 0.18u' as='int((nf+2)/2) * W/nf * 0.18u' pd='2*int((nf+1)/2) * (W/nf + 0.18u)' ps='2*int((nf+2)/2) * (W/nf + 0.18u)' nrd='0.18u / W' nrs='0.18u / W' sa=0 sb=0 sd=0
VR_m110 nref m110r 0
XO_m110 m110o m110r Vdd Vdd pfet_03v3 L=2.349u W=0.753u nf=1 ad='int((nf+1)/2) * W/nf * 0.18u' as='int((nf+2)/2) * W/nf * 0.18u' pd='2*int((nf+1)/2) * (W/nf + 0.18u)' ps='2*int((nf+2)/2) * (W/nf + 0.18u)' nrd='0.18u / W' nrs='0.18u / W' sa=0 sb=0 sd=0
VO_m110 m110o Vmem 0
XR_m111 m111r m111r Vdd Vdd pfet_03v3 L=0.286u W=0.454u nf=1 ad='int((nf+1)/2) * W/nf * 0.18u' as='int((nf+2)/2) * W/nf * 0.18u' pd='2*int((nf+1)/2) * (W/nf + 0.18u)' ps='2*int((nf+2)/2) * (W/nf + 0.18u)' nrd='0.18u / W' nrs='0.18u / W' sa=0 sb=0 sd=0
VR_m111 nref m111r 0
XO_m111 m111o m111r Vdd Vdd pfet_03v3 L=0.808u W=0.662u nf=1 ad='int((nf+1)/2) * W/nf * 0.18u' as='int((nf+2)/2) * W/nf * 0.18u' pd='2*int((nf+1)/2) * (W/nf + 0.18u)' ps='2*int((nf+2)/2) * (W/nf + 0.18u)' nrd='0.18u / W' nrs='0.18u / W' sa=0 sb=0 sd=0
VO_m111 m111o Vmem 0
XR_m112 m112r m112r Vdd Vdd pfet_03v3 L=2.152u W=0.55u nf=1 ad='int((nf+1)/2) * W/nf * 0.18u' as='int((nf+2)/2) * W/nf * 0.18u' pd='2*int((nf+1)/2) * (W/nf + 0.18u)' ps='2*int((nf+2)/2) * (W/nf + 0.18u)' nrd='0.18u / W' nrs='0.18u / W' sa=0 sb=0 sd=0
VR_m112 nref m112r 0
XO_m112 m112o m112r Vdd Vdd pfet_03v3 L=6.324u W=1.641u nf=1 ad='int((nf+1)/2) * W/nf * 0.18u' as='int((nf+2)/2) * W/nf * 0.18u' pd='2*int((nf+1)/2) * (W/nf + 0.18u)' ps='2*int((nf+2)/2) * (W/nf + 0.18u)' nrd='0.18u / W' nrs='0.18u / W' sa=0 sb=0 sd=0
VO_m112 m112o Vmem 0
XR_m113 m113r m113r Vdd Vdd pfet_03v3 L=0.285u W=0.499u nf=1 ad='int((nf+1)/2) * W/nf * 0.18u' as='int((nf+2)/2) * W/nf * 0.18u' pd='2*int((nf+1)/2) * (W/nf + 0.18u)' ps='2*int((nf+2)/2) * (W/nf + 0.18u)' nrd='0.18u / W' nrs='0.18u / W' sa=0 sb=0 sd=0
VR_m113 nref m113r 0
XO_m113 m113o m113r Vdd Vdd pfet_03v3 L=0.652u W=0.692u nf=1 ad='int((nf+1)/2) * W/nf * 0.18u' as='int((nf+2)/2) * W/nf * 0.18u' pd='2*int((nf+1)/2) * (W/nf + 0.18u)' ps='2*int((nf+2)/2) * (W/nf + 0.18u)' nrd='0.18u / W' nrs='0.18u / W' sa=0 sb=0 sd=0
VO_m113 m113o Vmem 0
XR_m114 m114r m114r Vdd Vdd pfet_03v3 L=1.704u W=1.918u nf=1 ad='int((nf+1)/2) * W/nf * 0.18u' as='int((nf+2)/2) * W/nf * 0.18u' pd='2*int((nf+1)/2) * (W/nf + 0.18u)' ps='2*int((nf+2)/2) * (W/nf + 0.18u)' nrd='0.18u / W' nrs='0.18u / W' sa=0 sb=0 sd=0
VR_m114 nref m114r 0
XO_m114 m114o m114r Vdd Vdd pfet_03v3 L=0.656u W=0.529u nf=1 ad='int((nf+1)/2) * W/nf * 0.18u' as='int((nf+2)/2) * W/nf * 0.18u' pd='2*int((nf+1)/2) * (W/nf + 0.18u)' ps='2*int((nf+2)/2) * (W/nf + 0.18u)' nrd='0.18u / W' nrs='0.18u / W' sa=0 sb=0 sd=0
VO_m114 m114o Vmem 0
XR_m115 m115r m115r Vdd Vdd pfet_03v3 L=0.462u W=0.546u nf=1 ad='int((nf+1)/2) * W/nf * 0.18u' as='int((nf+2)/2) * W/nf * 0.18u' pd='2*int((nf+1)/2) * (W/nf + 0.18u)' ps='2*int((nf+2)/2) * (W/nf + 0.18u)' nrd='0.18u / W' nrs='0.18u / W' sa=0 sb=0 sd=0
VR_m115 nref m115r 0
XO_m115 m115o m115r Vdd Vdd pfet_03v3 L=1.064u W=1.904u nf=1 ad='int((nf+1)/2) * W/nf * 0.18u' as='int((nf+2)/2) * W/nf * 0.18u' pd='2*int((nf+1)/2) * (W/nf + 0.18u)' ps='2*int((nf+2)/2) * (W/nf + 0.18u)' nrd='0.18u / W' nrs='0.18u / W' sa=0 sb=0 sd=0
VO_m115 m115o Vmem 0
XR_m116 m116r m116r Vdd Vdd pfet_03v3 L=2.305u W=0.424u nf=1 ad='int((nf+1)/2) * W/nf * 0.18u' as='int((nf+2)/2) * W/nf * 0.18u' pd='2*int((nf+1)/2) * (W/nf + 0.18u)' ps='2*int((nf+2)/2) * (W/nf + 0.18u)' nrd='0.18u / W' nrs='0.18u / W' sa=0 sb=0 sd=0
VR_m116 nref m116r 0
XO_m116 m116o m116r Vdd Vdd pfet_03v3 L=0.712u W=0.269u nf=1 ad='int((nf+1)/2) * W/nf * 0.18u' as='int((nf+2)/2) * W/nf * 0.18u' pd='2*int((nf+1)/2) * (W/nf + 0.18u)' ps='2*int((nf+2)/2) * (W/nf + 0.18u)' nrd='0.18u / W' nrs='0.18u / W' sa=0 sb=0 sd=0
VO_m116 m116o Vmem 0
XR_m117 m117r m117r Vdd Vdd pfet_03v3 L=0.419u W=0.335u nf=1 ad='int((nf+1)/2) * W/nf * 0.18u' as='int((nf+2)/2) * W/nf * 0.18u' pd='2*int((nf+1)/2) * (W/nf + 0.18u)' ps='2*int((nf+2)/2) * (W/nf + 0.18u)' nrd='0.18u / W' nrs='0.18u / W' sa=0 sb=0 sd=0
VR_m117 nref m117r 0
XO_m117 m117o m117r Vdd Vdd pfet_03v3 L=1.705u W=0.265u nf=1 ad='int((nf+1)/2) * W/nf * 0.18u' as='int((nf+2)/2) * W/nf * 0.18u' pd='2*int((nf+1)/2) * (W/nf + 0.18u)' ps='2*int((nf+2)/2) * (W/nf + 0.18u)' nrd='0.18u / W' nrs='0.18u / W' sa=0 sb=0 sd=0
VO_m117 m117o Vmem 0
XR_m118 m118r m118r Vdd Vdd pfet_03v3 L=3.772u W=0.488u nf=1 ad='int((nf+1)/2) * W/nf * 0.18u' as='int((nf+2)/2) * W/nf * 0.18u' pd='2*int((nf+1)/2) * (W/nf + 0.18u)' ps='2*int((nf+2)/2) * (W/nf + 0.18u)' nrd='0.18u / W' nrs='0.18u / W' sa=0 sb=0 sd=0
VR_m118 nref m118r 0
XO_m118 m118o m118r Vdd Vdd pfet_03v3 L=0.568u W=0.221u nf=1 ad='int((nf+1)/2) * W/nf * 0.18u' as='int((nf+2)/2) * W/nf * 0.18u' pd='2*int((nf+1)/2) * (W/nf + 0.18u)' ps='2*int((nf+2)/2) * (W/nf + 0.18u)' nrd='0.18u / W' nrs='0.18u / W' sa=0 sb=0 sd=0
VO_m118 m118o Vmem 0
XR_m119 m119r m119r Vdd Vdd pfet_03v3 L=2.285u W=0.768u nf=1 ad='int((nf+1)/2) * W/nf * 0.18u' as='int((nf+2)/2) * W/nf * 0.18u' pd='2*int((nf+1)/2) * (W/nf + 0.18u)' ps='2*int((nf+2)/2) * (W/nf + 0.18u)' nrd='0.18u / W' nrs='0.18u / W' sa=0 sb=0 sd=0
VR_m119 nref m119r 0
XO_m119 m119o m119r Vdd Vdd pfet_03v3 L=1.687u W=2.149u nf=1 ad='int((nf+1)/2) * W/nf * 0.18u' as='int((nf+2)/2) * W/nf * 0.18u' pd='2*int((nf+1)/2) * (W/nf + 0.18u)' ps='2*int((nf+2)/2) * (W/nf + 0.18u)' nrd='0.18u / W' nrs='0.18u / W' sa=0 sb=0 sd=0
VO_m119 m119o Vmem 0
XR_m120 m120r m120r Vdd Vdd pfet_03v3 L=3.893u W=1.804u nf=1 ad='int((nf+1)/2) * W/nf * 0.18u' as='int((nf+2)/2) * W/nf * 0.18u' pd='2*int((nf+1)/2) * (W/nf + 0.18u)' ps='2*int((nf+2)/2) * (W/nf + 0.18u)' nrd='0.18u / W' nrs='0.18u / W' sa=0 sb=0 sd=0
VR_m120 nref m120r 0
XO_m120 m120o m120r Vdd Vdd pfet_03v3 L=1.146u W=0.73u nf=1 ad='int((nf+1)/2) * W/nf * 0.18u' as='int((nf+2)/2) * W/nf * 0.18u' pd='2*int((nf+1)/2) * (W/nf + 0.18u)' ps='2*int((nf+2)/2) * (W/nf + 0.18u)' nrd='0.18u / W' nrs='0.18u / W' sa=0 sb=0 sd=0
VO_m120 m120o Vmem 0
XR_m121 m121r m121r Vdd Vdd pfet_03v3 L=0.556u W=1.027u nf=1 ad='int((nf+1)/2) * W/nf * 0.18u' as='int((nf+2)/2) * W/nf * 0.18u' pd='2*int((nf+1)/2) * (W/nf + 0.18u)' ps='2*int((nf+2)/2) * (W/nf + 0.18u)' nrd='0.18u / W' nrs='0.18u / W' sa=0 sb=0 sd=0
VR_m121 nref m121r 0
XO_m121 m121o m121r Vdd Vdd pfet_03v3 L=0.295u W=3.748u nf=1 ad='int((nf+1)/2) * W/nf * 0.18u' as='int((nf+2)/2) * W/nf * 0.18u' pd='2*int((nf+1)/2) * (W/nf + 0.18u)' ps='2*int((nf+2)/2) * (W/nf + 0.18u)' nrd='0.18u / W' nrs='0.18u / W' sa=0 sb=0 sd=0
VO_m121 m121o Vmem 0
XR_m122 m122r m122r Vdd Vdd pfet_03v3 L=0.483u W=0.578u nf=1 ad='int((nf+1)/2) * W/nf * 0.18u' as='int((nf+2)/2) * W/nf * 0.18u' pd='2*int((nf+1)/2) * (W/nf + 0.18u)' ps='2*int((nf+2)/2) * (W/nf + 0.18u)' nrd='0.18u / W' nrs='0.18u / W' sa=0 sb=0 sd=0
VR_m122 nref m122r 0
XO_m122 m122o m122r Vdd Vdd pfet_03v3 L=0.909u W=0.932u nf=1 ad='int((nf+1)/2) * W/nf * 0.18u' as='int((nf+2)/2) * W/nf * 0.18u' pd='2*int((nf+1)/2) * (W/nf + 0.18u)' ps='2*int((nf+2)/2) * (W/nf + 0.18u)' nrd='0.18u / W' nrs='0.18u / W' sa=0 sb=0 sd=0
VO_m122 m122o Vmem 0
XR_m123 m123r m123r Vdd Vdd pfet_03v3 L=3.574u W=0.361u nf=1 ad='int((nf+1)/2) * W/nf * 0.18u' as='int((nf+2)/2) * W/nf * 0.18u' pd='2*int((nf+1)/2) * (W/nf + 0.18u)' ps='2*int((nf+2)/2) * (W/nf + 0.18u)' nrd='0.18u / W' nrs='0.18u / W' sa=0 sb=0 sd=0
VR_m123 nref m123r 0
XO_m123 m123o m123r Vdd Vdd pfet_03v3 L=0.341u W=0.693u nf=1 ad='int((nf+1)/2) * W/nf * 0.18u' as='int((nf+2)/2) * W/nf * 0.18u' pd='2*int((nf+1)/2) * (W/nf + 0.18u)' ps='2*int((nf+2)/2) * (W/nf + 0.18u)' nrd='0.18u / W' nrs='0.18u / W' sa=0 sb=0 sd=0
VO_m123 m123o Vmem 0
XR_m124 m124r m124r Vdd Vdd pfet_03v3 L=0.725u W=2.281u nf=1 ad='int((nf+1)/2) * W/nf * 0.18u' as='int((nf+2)/2) * W/nf * 0.18u' pd='2*int((nf+1)/2) * (W/nf + 0.18u)' ps='2*int((nf+2)/2) * (W/nf + 0.18u)' nrd='0.18u / W' nrs='0.18u / W' sa=0 sb=0 sd=0
VR_m124 nref m124r 0
XO_m124 m124o m124r Vdd Vdd pfet_03v3 L=0.4u W=1.372u nf=1 ad='int((nf+1)/2) * W/nf * 0.18u' as='int((nf+2)/2) * W/nf * 0.18u' pd='2*int((nf+1)/2) * (W/nf + 0.18u)' ps='2*int((nf+2)/2) * (W/nf + 0.18u)' nrd='0.18u / W' nrs='0.18u / W' sa=0 sb=0 sd=0
VO_m124 m124o Vmem 0
XR_m125 m125r m125r Vdd Vdd pfet_03v3 L=1.432u W=1.504u nf=1 ad='int((nf+1)/2) * W/nf * 0.18u' as='int((nf+2)/2) * W/nf * 0.18u' pd='2*int((nf+1)/2) * (W/nf + 0.18u)' ps='2*int((nf+2)/2) * (W/nf + 0.18u)' nrd='0.18u / W' nrs='0.18u / W' sa=0 sb=0 sd=0
VR_m125 nref m125r 0
XO_m125 m125o m125r Vdd Vdd pfet_03v3 L=0.965u W=3.72u nf=1 ad='int((nf+1)/2) * W/nf * 0.18u' as='int((nf+2)/2) * W/nf * 0.18u' pd='2*int((nf+1)/2) * (W/nf + 0.18u)' ps='2*int((nf+2)/2) * (W/nf + 0.18u)' nrd='0.18u / W' nrs='0.18u / W' sa=0 sb=0 sd=0
VO_m125 m125o Vmem 0
XR_m126 m126r m126r Vdd Vdd pfet_03v3 L=3.326u W=1.223u nf=1 ad='int((nf+1)/2) * W/nf * 0.18u' as='int((nf+2)/2) * W/nf * 0.18u' pd='2*int((nf+1)/2) * (W/nf + 0.18u)' ps='2*int((nf+2)/2) * (W/nf + 0.18u)' nrd='0.18u / W' nrs='0.18u / W' sa=0 sb=0 sd=0
VR_m126 nref m126r 0
XO_m126 m126o m126r Vdd Vdd pfet_03v3 L=1.579u W=0.415u nf=1 ad='int((nf+1)/2) * W/nf * 0.18u' as='int((nf+2)/2) * W/nf * 0.18u' pd='2*int((nf+1)/2) * (W/nf + 0.18u)' ps='2*int((nf+2)/2) * (W/nf + 0.18u)' nrd='0.18u / W' nrs='0.18u / W' sa=0 sb=0 sd=0
VO_m126 m126o Vmem 0
XR_m127 m127r m127r Vdd Vdd pfet_03v3 L=0.351u W=1.961u nf=1 ad='int((nf+1)/2) * W/nf * 0.18u' as='int((nf+2)/2) * W/nf * 0.18u' pd='2*int((nf+1)/2) * (W/nf + 0.18u)' ps='2*int((nf+2)/2) * (W/nf + 0.18u)' nrd='0.18u / W' nrs='0.18u / W' sa=0 sb=0 sd=0
VR_m127 nref m127r 0
XO_m127 m127o m127r Vdd Vdd pfet_03v3 L=1.461u W=3.314u nf=1 ad='int((nf+1)/2) * W/nf * 0.18u' as='int((nf+2)/2) * W/nf * 0.18u' pd='2*int((nf+1)/2) * (W/nf + 0.18u)' ps='2*int((nf+2)/2) * (W/nf + 0.18u)' nrd='0.18u / W' nrs='0.18u / W' sa=0 sb=0 sd=0
VO_m127 m127o Vmem 0
XR_m128 m128r m128r Vdd Vdd pfet_03v3 L=0.331u W=1.827u nf=1 ad='int((nf+1)/2) * W/nf * 0.18u' as='int((nf+2)/2) * W/nf * 0.18u' pd='2*int((nf+1)/2) * (W/nf + 0.18u)' ps='2*int((nf+2)/2) * (W/nf + 0.18u)' nrd='0.18u / W' nrs='0.18u / W' sa=0 sb=0 sd=0
VR_m128 nref m128r 0
XO_m128 m128o m128r Vdd Vdd pfet_03v3 L=0.887u W=0.258u nf=1 ad='int((nf+1)/2) * W/nf * 0.18u' as='int((nf+2)/2) * W/nf * 0.18u' pd='2*int((nf+1)/2) * (W/nf + 0.18u)' ps='2*int((nf+2)/2) * (W/nf + 0.18u)' nrd='0.18u / W' nrs='0.18u / W' sa=0 sb=0 sd=0
VO_m128 m128o Vmem 0
XR_m129 m129r m129r Vdd Vdd pfet_03v3 L=2.612u W=1.057u nf=1 ad='int((nf+1)/2) * W/nf * 0.18u' as='int((nf+2)/2) * W/nf * 0.18u' pd='2*int((nf+1)/2) * (W/nf + 0.18u)' ps='2*int((nf+2)/2) * (W/nf + 0.18u)' nrd='0.18u / W' nrs='0.18u / W' sa=0 sb=0 sd=0
VR_m129 nref m129r 0
XO_m129 m129o m129r Vdd Vdd pfet_03v3 L=3.284u W=0.498u nf=1 ad='int((nf+1)/2) * W/nf * 0.18u' as='int((nf+2)/2) * W/nf * 0.18u' pd='2*int((nf+1)/2) * (W/nf + 0.18u)' ps='2*int((nf+2)/2) * (W/nf + 0.18u)' nrd='0.18u / W' nrs='0.18u / W' sa=0 sb=0 sd=0
VO_m129 m129o Vmem 0
XR_m130 m130r m130r Vdd Vdd pfet_03v3 L=1.226u W=2.179u nf=1 ad='int((nf+1)/2) * W/nf * 0.18u' as='int((nf+2)/2) * W/nf * 0.18u' pd='2*int((nf+1)/2) * (W/nf + 0.18u)' ps='2*int((nf+2)/2) * (W/nf + 0.18u)' nrd='0.18u / W' nrs='0.18u / W' sa=0 sb=0 sd=0
VR_m130 nref m130r 0
XO_m130 m130o m130r Vdd Vdd pfet_03v3 L=1.691u W=0.224u nf=1 ad='int((nf+1)/2) * W/nf * 0.18u' as='int((nf+2)/2) * W/nf * 0.18u' pd='2*int((nf+1)/2) * (W/nf + 0.18u)' ps='2*int((nf+2)/2) * (W/nf + 0.18u)' nrd='0.18u / W' nrs='0.18u / W' sa=0 sb=0 sd=0
VO_m130 m130o Vmem 0
XR_m131 m131r m131r Vdd Vdd pfet_03v3 L=3.335u W=3.929u nf=1 ad='int((nf+1)/2) * W/nf * 0.18u' as='int((nf+2)/2) * W/nf * 0.18u' pd='2*int((nf+1)/2) * (W/nf + 0.18u)' ps='2*int((nf+2)/2) * (W/nf + 0.18u)' nrd='0.18u / W' nrs='0.18u / W' sa=0 sb=0 sd=0
VR_m131 nref m131r 0
XO_m131 m131o m131r Vdd Vdd pfet_03v3 L=0.34u W=0.292u nf=1 ad='int((nf+1)/2) * W/nf * 0.18u' as='int((nf+2)/2) * W/nf * 0.18u' pd='2*int((nf+1)/2) * (W/nf + 0.18u)' ps='2*int((nf+2)/2) * (W/nf + 0.18u)' nrd='0.18u / W' nrs='0.18u / W' sa=0 sb=0 sd=0
VO_m131 m131o Vmem 0
XR_m132 m132r m132r Vdd Vdd pfet_03v3 L=0.775u W=3.121u nf=1 ad='int((nf+1)/2) * W/nf * 0.18u' as='int((nf+2)/2) * W/nf * 0.18u' pd='2*int((nf+1)/2) * (W/nf + 0.18u)' ps='2*int((nf+2)/2) * (W/nf + 0.18u)' nrd='0.18u / W' nrs='0.18u / W' sa=0 sb=0 sd=0
VR_m132 nref m132r 0
XO_m132 m132o m132r Vdd Vdd pfet_03v3 L=0.366u W=1.605u nf=1 ad='int((nf+1)/2) * W/nf * 0.18u' as='int((nf+2)/2) * W/nf * 0.18u' pd='2*int((nf+1)/2) * (W/nf + 0.18u)' ps='2*int((nf+2)/2) * (W/nf + 0.18u)' nrd='0.18u / W' nrs='0.18u / W' sa=0 sb=0 sd=0
VO_m132 m132o Vmem 0
XR_m133 m133r m133r Vdd Vdd pfet_03v3 L=3.008u W=0.587u nf=1 ad='int((nf+1)/2) * W/nf * 0.18u' as='int((nf+2)/2) * W/nf * 0.18u' pd='2*int((nf+1)/2) * (W/nf + 0.18u)' ps='2*int((nf+2)/2) * (W/nf + 0.18u)' nrd='0.18u / W' nrs='0.18u / W' sa=0 sb=0 sd=0
VR_m133 nref m133r 0
XO_m133 m133o m133r Vdd Vdd pfet_03v3 L=0.782u W=1.408u nf=1 ad='int((nf+1)/2) * W/nf * 0.18u' as='int((nf+2)/2) * W/nf * 0.18u' pd='2*int((nf+1)/2) * (W/nf + 0.18u)' ps='2*int((nf+2)/2) * (W/nf + 0.18u)' nrd='0.18u / W' nrs='0.18u / W' sa=0 sb=0 sd=0
VO_m133 m133o Vmem 0
XR_m134 m134r m134r Vdd Vdd pfet_03v3 L=0.519u W=0.886u nf=1 ad='int((nf+1)/2) * W/nf * 0.18u' as='int((nf+2)/2) * W/nf * 0.18u' pd='2*int((nf+1)/2) * (W/nf + 0.18u)' ps='2*int((nf+2)/2) * (W/nf + 0.18u)' nrd='0.18u / W' nrs='0.18u / W' sa=0 sb=0 sd=0
VR_m134 nref m134r 0
XO_m134 m134o m134r Vdd Vdd pfet_03v3 L=0.597u W=0.34u nf=1 ad='int((nf+1)/2) * W/nf * 0.18u' as='int((nf+2)/2) * W/nf * 0.18u' pd='2*int((nf+1)/2) * (W/nf + 0.18u)' ps='2*int((nf+2)/2) * (W/nf + 0.18u)' nrd='0.18u / W' nrs='0.18u / W' sa=0 sb=0 sd=0
VO_m134 m134o Vmem 0
XR_m135 m135r m135r Vdd Vdd pfet_03v3 L=0.751u W=0.29u nf=1 ad='int((nf+1)/2) * W/nf * 0.18u' as='int((nf+2)/2) * W/nf * 0.18u' pd='2*int((nf+1)/2) * (W/nf + 0.18u)' ps='2*int((nf+2)/2) * (W/nf + 0.18u)' nrd='0.18u / W' nrs='0.18u / W' sa=0 sb=0 sd=0
VR_m135 nref m135r 0
XO_m135 m135o m135r Vdd Vdd pfet_03v3 L=7.633u W=2.091u nf=1 ad='int((nf+1)/2) * W/nf * 0.18u' as='int((nf+2)/2) * W/nf * 0.18u' pd='2*int((nf+1)/2) * (W/nf + 0.18u)' ps='2*int((nf+2)/2) * (W/nf + 0.18u)' nrd='0.18u / W' nrs='0.18u / W' sa=0 sb=0 sd=0
VO_m135 m135o Vmem 0
XR_m136 m136r m136r Vdd Vdd pfet_03v3 L=0.7u W=1.637u nf=1 ad='int((nf+1)/2) * W/nf * 0.18u' as='int((nf+2)/2) * W/nf * 0.18u' pd='2*int((nf+1)/2) * (W/nf + 0.18u)' ps='2*int((nf+2)/2) * (W/nf + 0.18u)' nrd='0.18u / W' nrs='0.18u / W' sa=0 sb=0 sd=0
VR_m136 nref m136r 0
XO_m136 m136o m136r Vdd Vdd pfet_03v3 L=0.42u W=2.814u nf=1 ad='int((nf+1)/2) * W/nf * 0.18u' as='int((nf+2)/2) * W/nf * 0.18u' pd='2*int((nf+1)/2) * (W/nf + 0.18u)' ps='2*int((nf+2)/2) * (W/nf + 0.18u)' nrd='0.18u / W' nrs='0.18u / W' sa=0 sb=0 sd=0
VO_m136 m136o Vmem 0
XR_m137 m137r m137r Vdd Vdd pfet_03v3 L=1.161u W=1.293u nf=1 ad='int((nf+1)/2) * W/nf * 0.18u' as='int((nf+2)/2) * W/nf * 0.18u' pd='2*int((nf+1)/2) * (W/nf + 0.18u)' ps='2*int((nf+2)/2) * (W/nf + 0.18u)' nrd='0.18u / W' nrs='0.18u / W' sa=0 sb=0 sd=0
VR_m137 nref m137r 0
XO_m137 m137o m137r Vdd Vdd pfet_03v3 L=3.775u W=1.459u nf=1 ad='int((nf+1)/2) * W/nf * 0.18u' as='int((nf+2)/2) * W/nf * 0.18u' pd='2*int((nf+1)/2) * (W/nf + 0.18u)' ps='2*int((nf+2)/2) * (W/nf + 0.18u)' nrd='0.18u / W' nrs='0.18u / W' sa=0 sb=0 sd=0
VO_m137 m137o Vmem 0
XR_m138 m138r m138r Vdd Vdd pfet_03v3 L=1.277u W=0.572u nf=1 ad='int((nf+1)/2) * W/nf * 0.18u' as='int((nf+2)/2) * W/nf * 0.18u' pd='2*int((nf+1)/2) * (W/nf + 0.18u)' ps='2*int((nf+2)/2) * (W/nf + 0.18u)' nrd='0.18u / W' nrs='0.18u / W' sa=0 sb=0 sd=0
VR_m138 nref m138r 0
XO_m138 m138o m138r Vdd Vdd pfet_03v3 L=0.426u W=1.779u nf=1 ad='int((nf+1)/2) * W/nf * 0.18u' as='int((nf+2)/2) * W/nf * 0.18u' pd='2*int((nf+1)/2) * (W/nf + 0.18u)' ps='2*int((nf+2)/2) * (W/nf + 0.18u)' nrd='0.18u / W' nrs='0.18u / W' sa=0 sb=0 sd=0
VO_m138 m138o Vmem 0
XR_m139 m139r m139r Vdd Vdd pfet_03v3 L=0.878u W=3.76u nf=1 ad='int((nf+1)/2) * W/nf * 0.18u' as='int((nf+2)/2) * W/nf * 0.18u' pd='2*int((nf+1)/2) * (W/nf + 0.18u)' ps='2*int((nf+2)/2) * (W/nf + 0.18u)' nrd='0.18u / W' nrs='0.18u / W' sa=0 sb=0 sd=0
VR_m139 nref m139r 0
XO_m139 m139o m139r Vdd Vdd pfet_03v3 L=0.394u W=3.483u nf=1 ad='int((nf+1)/2) * W/nf * 0.18u' as='int((nf+2)/2) * W/nf * 0.18u' pd='2*int((nf+1)/2) * (W/nf + 0.18u)' ps='2*int((nf+2)/2) * (W/nf + 0.18u)' nrd='0.18u / W' nrs='0.18u / W' sa=0 sb=0 sd=0
VO_m139 m139o Vmem 0
XR_m140 m140r m140r Vdd Vdd pfet_03v3 L=0.457u W=0.862u nf=1 ad='int((nf+1)/2) * W/nf * 0.18u' as='int((nf+2)/2) * W/nf * 0.18u' pd='2*int((nf+1)/2) * (W/nf + 0.18u)' ps='2*int((nf+2)/2) * (W/nf + 0.18u)' nrd='0.18u / W' nrs='0.18u / W' sa=0 sb=0 sd=0
VR_m140 nref m140r 0
XO_m140 m140o m140r Vdd Vdd pfet_03v3 L=0.752u W=1.226u nf=1 ad='int((nf+1)/2) * W/nf * 0.18u' as='int((nf+2)/2) * W/nf * 0.18u' pd='2*int((nf+1)/2) * (W/nf + 0.18u)' ps='2*int((nf+2)/2) * (W/nf + 0.18u)' nrd='0.18u / W' nrs='0.18u / W' sa=0 sb=0 sd=0
VO_m140 m140o Vmem 0
XR_m141 m141r m141r Vdd Vdd pfet_03v3 L=1.085u W=0.566u nf=1 ad='int((nf+1)/2) * W/nf * 0.18u' as='int((nf+2)/2) * W/nf * 0.18u' pd='2*int((nf+1)/2) * (W/nf + 0.18u)' ps='2*int((nf+2)/2) * (W/nf + 0.18u)' nrd='0.18u / W' nrs='0.18u / W' sa=0 sb=0 sd=0
VR_m141 nref m141r 0
XO_m141 m141o m141r Vdd Vdd pfet_03v3 L=0.511u W=3.94u nf=1 ad='int((nf+1)/2) * W/nf * 0.18u' as='int((nf+2)/2) * W/nf * 0.18u' pd='2*int((nf+1)/2) * (W/nf + 0.18u)' ps='2*int((nf+2)/2) * (W/nf + 0.18u)' nrd='0.18u / W' nrs='0.18u / W' sa=0 sb=0 sd=0
VO_m141 m141o Vmem 0
XR_m142 m142r m142r Vdd Vdd pfet_03v3 L=0.621u W=0.456u nf=1 ad='int((nf+1)/2) * W/nf * 0.18u' as='int((nf+2)/2) * W/nf * 0.18u' pd='2*int((nf+1)/2) * (W/nf + 0.18u)' ps='2*int((nf+2)/2) * (W/nf + 0.18u)' nrd='0.18u / W' nrs='0.18u / W' sa=0 sb=0 sd=0
VR_m142 nref m142r 0
XO_m142 m142o m142r Vdd Vdd pfet_03v3 L=1.391u W=1.402u nf=1 ad='int((nf+1)/2) * W/nf * 0.18u' as='int((nf+2)/2) * W/nf * 0.18u' pd='2*int((nf+1)/2) * (W/nf + 0.18u)' ps='2*int((nf+2)/2) * (W/nf + 0.18u)' nrd='0.18u / W' nrs='0.18u / W' sa=0 sb=0 sd=0
VO_m142 m142o Vmem 0
XR_m143 m143r m143r Vdd Vdd pfet_03v3 L=2.332u W=0.288u nf=1 ad='int((nf+1)/2) * W/nf * 0.18u' as='int((nf+2)/2) * W/nf * 0.18u' pd='2*int((nf+1)/2) * (W/nf + 0.18u)' ps='2*int((nf+2)/2) * (W/nf + 0.18u)' nrd='0.18u / W' nrs='0.18u / W' sa=0 sb=0 sd=0
VR_m143 nref m143r 0
XO_m143 m143o m143r Vdd Vdd pfet_03v3 L=0.489u W=0.239u nf=1 ad='int((nf+1)/2) * W/nf * 0.18u' as='int((nf+2)/2) * W/nf * 0.18u' pd='2*int((nf+1)/2) * (W/nf + 0.18u)' ps='2*int((nf+2)/2) * (W/nf + 0.18u)' nrd='0.18u / W' nrs='0.18u / W' sa=0 sb=0 sd=0
VO_m143 m143o Vmem 0
XR_m144 m144r m144r Vdd Vdd pfet_03v3 L=1.1u W=0.507u nf=1 ad='int((nf+1)/2) * W/nf * 0.18u' as='int((nf+2)/2) * W/nf * 0.18u' pd='2*int((nf+1)/2) * (W/nf + 0.18u)' ps='2*int((nf+2)/2) * (W/nf + 0.18u)' nrd='0.18u / W' nrs='0.18u / W' sa=0 sb=0 sd=0
VR_m144 nref m144r 0
XO_m144 m144o m144r Vdd Vdd pfet_03v3 L=0.925u W=2.727u nf=1 ad='int((nf+1)/2) * W/nf * 0.18u' as='int((nf+2)/2) * W/nf * 0.18u' pd='2*int((nf+1)/2) * (W/nf + 0.18u)' ps='2*int((nf+2)/2) * (W/nf + 0.18u)' nrd='0.18u / W' nrs='0.18u / W' sa=0 sb=0 sd=0
VO_m144 m144o Vmem 0
XR_m145 m145r m145r Vdd Vdd pfet_03v3 L=0.607u W=3.274u nf=1 ad='int((nf+1)/2) * W/nf * 0.18u' as='int((nf+2)/2) * W/nf * 0.18u' pd='2*int((nf+1)/2) * (W/nf + 0.18u)' ps='2*int((nf+2)/2) * (W/nf + 0.18u)' nrd='0.18u / W' nrs='0.18u / W' sa=0 sb=0 sd=0
VR_m145 nref m145r 0
XO_m145 m145o m145r Vdd Vdd pfet_03v3 L=0.957u W=0.243u nf=1 ad='int((nf+1)/2) * W/nf * 0.18u' as='int((nf+2)/2) * W/nf * 0.18u' pd='2*int((nf+1)/2) * (W/nf + 0.18u)' ps='2*int((nf+2)/2) * (W/nf + 0.18u)' nrd='0.18u / W' nrs='0.18u / W' sa=0 sb=0 sd=0
VO_m145 m145o Vmem 0
XR_m146 m146r m146r Vdd Vdd pfet_03v3 L=2.872u W=1.565u nf=1 ad='int((nf+1)/2) * W/nf * 0.18u' as='int((nf+2)/2) * W/nf * 0.18u' pd='2*int((nf+1)/2) * (W/nf + 0.18u)' ps='2*int((nf+2)/2) * (W/nf + 0.18u)' nrd='0.18u / W' nrs='0.18u / W' sa=0 sb=0 sd=0
VR_m146 nref m146r 0
XO_m146 m146o m146r Vdd Vdd pfet_03v3 L=1.497u W=2.422u nf=1 ad='int((nf+1)/2) * W/nf * 0.18u' as='int((nf+2)/2) * W/nf * 0.18u' pd='2*int((nf+1)/2) * (W/nf + 0.18u)' ps='2*int((nf+2)/2) * (W/nf + 0.18u)' nrd='0.18u / W' nrs='0.18u / W' sa=0 sb=0 sd=0
VO_m146 m146o Vmem 0
XR_m147 m147r m147r Vdd Vdd pfet_03v3 L=1.649u W=2.537u nf=1 ad='int((nf+1)/2) * W/nf * 0.18u' as='int((nf+2)/2) * W/nf * 0.18u' pd='2*int((nf+1)/2) * (W/nf + 0.18u)' ps='2*int((nf+2)/2) * (W/nf + 0.18u)' nrd='0.18u / W' nrs='0.18u / W' sa=0 sb=0 sd=0
VR_m147 nref m147r 0
XO_m147 m147o m147r Vdd Vdd pfet_03v3 L=2.48u W=0.225u nf=1 ad='int((nf+1)/2) * W/nf * 0.18u' as='int((nf+2)/2) * W/nf * 0.18u' pd='2*int((nf+1)/2) * (W/nf + 0.18u)' ps='2*int((nf+2)/2) * (W/nf + 0.18u)' nrd='0.18u / W' nrs='0.18u / W' sa=0 sb=0 sd=0
VO_m147 m147o Vmem 0
XR_m148 m148r m148r Vdd Vdd pfet_03v3 L=2.714u W=0.455u nf=1 ad='int((nf+1)/2) * W/nf * 0.18u' as='int((nf+2)/2) * W/nf * 0.18u' pd='2*int((nf+1)/2) * (W/nf + 0.18u)' ps='2*int((nf+2)/2) * (W/nf + 0.18u)' nrd='0.18u / W' nrs='0.18u / W' sa=0 sb=0 sd=0
VR_m148 nref m148r 0
XO_m148 m148o m148r Vdd Vdd pfet_03v3 L=5.655u W=0.368u nf=1 ad='int((nf+1)/2) * W/nf * 0.18u' as='int((nf+2)/2) * W/nf * 0.18u' pd='2*int((nf+1)/2) * (W/nf + 0.18u)' ps='2*int((nf+2)/2) * (W/nf + 0.18u)' nrd='0.18u / W' nrs='0.18u / W' sa=0 sb=0 sd=0
VO_m148 m148o Vmem 0
XR_m149 m149r m149r Vdd Vdd pfet_03v3 L=1.091u W=0.248u nf=1 ad='int((nf+1)/2) * W/nf * 0.18u' as='int((nf+2)/2) * W/nf * 0.18u' pd='2*int((nf+1)/2) * (W/nf + 0.18u)' ps='2*int((nf+2)/2) * (W/nf + 0.18u)' nrd='0.18u / W' nrs='0.18u / W' sa=0 sb=0 sd=0
VR_m149 nref m149r 0
XO_m149 m149o m149r Vdd Vdd pfet_03v3 L=7.792u W=1.908u nf=1 ad='int((nf+1)/2) * W/nf * 0.18u' as='int((nf+2)/2) * W/nf * 0.18u' pd='2*int((nf+1)/2) * (W/nf + 0.18u)' ps='2*int((nf+2)/2) * (W/nf + 0.18u)' nrd='0.18u / W' nrs='0.18u / W' sa=0 sb=0 sd=0
VO_m149 m149o Vmem 0
XR_m150 m150r m150r Vdd Vdd pfet_03v3 L=0.334u W=1.034u nf=1 ad='int((nf+1)/2) * W/nf * 0.18u' as='int((nf+2)/2) * W/nf * 0.18u' pd='2*int((nf+1)/2) * (W/nf + 0.18u)' ps='2*int((nf+2)/2) * (W/nf + 0.18u)' nrd='0.18u / W' nrs='0.18u / W' sa=0 sb=0 sd=0
VR_m150 nref m150r 0
XO_m150 m150o m150r Vdd Vdd pfet_03v3 L=3.082u W=1.335u nf=1 ad='int((nf+1)/2) * W/nf * 0.18u' as='int((nf+2)/2) * W/nf * 0.18u' pd='2*int((nf+1)/2) * (W/nf + 0.18u)' ps='2*int((nf+2)/2) * (W/nf + 0.18u)' nrd='0.18u / W' nrs='0.18u / W' sa=0 sb=0 sd=0
VO_m150 m150o Vmem 0
XR_m151 m151r m151r Vdd Vdd pfet_03v3 L=1.813u W=0.613u nf=1 ad='int((nf+1)/2) * W/nf * 0.18u' as='int((nf+2)/2) * W/nf * 0.18u' pd='2*int((nf+1)/2) * (W/nf + 0.18u)' ps='2*int((nf+2)/2) * (W/nf + 0.18u)' nrd='0.18u / W' nrs='0.18u / W' sa=0 sb=0 sd=0
VR_m151 nref m151r 0
XO_m151 m151o m151r Vdd Vdd pfet_03v3 L=0.516u W=2.795u nf=1 ad='int((nf+1)/2) * W/nf * 0.18u' as='int((nf+2)/2) * W/nf * 0.18u' pd='2*int((nf+1)/2) * (W/nf + 0.18u)' ps='2*int((nf+2)/2) * (W/nf + 0.18u)' nrd='0.18u / W' nrs='0.18u / W' sa=0 sb=0 sd=0
VO_m151 m151o Vmem 0
XR_m152 m152r m152r Vdd Vdd pfet_03v3 L=0.456u W=0.33u nf=1 ad='int((nf+1)/2) * W/nf * 0.18u' as='int((nf+2)/2) * W/nf * 0.18u' pd='2*int((nf+1)/2) * (W/nf + 0.18u)' ps='2*int((nf+2)/2) * (W/nf + 0.18u)' nrd='0.18u / W' nrs='0.18u / W' sa=0 sb=0 sd=0
VR_m152 nref m152r 0
XO_m152 m152o m152r Vdd Vdd pfet_03v3 L=1.567u W=0.434u nf=1 ad='int((nf+1)/2) * W/nf * 0.18u' as='int((nf+2)/2) * W/nf * 0.18u' pd='2*int((nf+1)/2) * (W/nf + 0.18u)' ps='2*int((nf+2)/2) * (W/nf + 0.18u)' nrd='0.18u / W' nrs='0.18u / W' sa=0 sb=0 sd=0
VO_m152 m152o Vmem 0
XR_m153 m153r m153r Vdd Vdd pfet_03v3 L=2.564u W=1.967u nf=1 ad='int((nf+1)/2) * W/nf * 0.18u' as='int((nf+2)/2) * W/nf * 0.18u' pd='2*int((nf+1)/2) * (W/nf + 0.18u)' ps='2*int((nf+2)/2) * (W/nf + 0.18u)' nrd='0.18u / W' nrs='0.18u / W' sa=0 sb=0 sd=0
VR_m153 nref m153r 0
XO_m153 m153o m153r Vdd Vdd pfet_03v3 L=0.517u W=0.238u nf=1 ad='int((nf+1)/2) * W/nf * 0.18u' as='int((nf+2)/2) * W/nf * 0.18u' pd='2*int((nf+1)/2) * (W/nf + 0.18u)' ps='2*int((nf+2)/2) * (W/nf + 0.18u)' nrd='0.18u / W' nrs='0.18u / W' sa=0 sb=0 sd=0
VO_m153 m153o Vmem 0
XR_m154 m154r m154r Vdd Vdd pfet_03v3 L=2.251u W=0.563u nf=1 ad='int((nf+1)/2) * W/nf * 0.18u' as='int((nf+2)/2) * W/nf * 0.18u' pd='2*int((nf+1)/2) * (W/nf + 0.18u)' ps='2*int((nf+2)/2) * (W/nf + 0.18u)' nrd='0.18u / W' nrs='0.18u / W' sa=0 sb=0 sd=0
VR_m154 nref m154r 0
XO_m154 m154o m154r Vdd Vdd pfet_03v3 L=1.836u W=0.484u nf=1 ad='int((nf+1)/2) * W/nf * 0.18u' as='int((nf+2)/2) * W/nf * 0.18u' pd='2*int((nf+1)/2) * (W/nf + 0.18u)' ps='2*int((nf+2)/2) * (W/nf + 0.18u)' nrd='0.18u / W' nrs='0.18u / W' sa=0 sb=0 sd=0
VO_m154 m154o Vmem 0
XR_m155 m155r m155r Vdd Vdd pfet_03v3 L=2.547u W=0.613u nf=1 ad='int((nf+1)/2) * W/nf * 0.18u' as='int((nf+2)/2) * W/nf * 0.18u' pd='2*int((nf+1)/2) * (W/nf + 0.18u)' ps='2*int((nf+2)/2) * (W/nf + 0.18u)' nrd='0.18u / W' nrs='0.18u / W' sa=0 sb=0 sd=0
VR_m155 nref m155r 0
XO_m155 m155o m155r Vdd Vdd pfet_03v3 L=4.571u W=0.434u nf=1 ad='int((nf+1)/2) * W/nf * 0.18u' as='int((nf+2)/2) * W/nf * 0.18u' pd='2*int((nf+1)/2) * (W/nf + 0.18u)' ps='2*int((nf+2)/2) * (W/nf + 0.18u)' nrd='0.18u / W' nrs='0.18u / W' sa=0 sb=0 sd=0
VO_m155 m155o Vmem 0
XR_m156 m156r m156r Vdd Vdd pfet_03v3 L=0.508u W=1.26u nf=1 ad='int((nf+1)/2) * W/nf * 0.18u' as='int((nf+2)/2) * W/nf * 0.18u' pd='2*int((nf+1)/2) * (W/nf + 0.18u)' ps='2*int((nf+2)/2) * (W/nf + 0.18u)' nrd='0.18u / W' nrs='0.18u / W' sa=0 sb=0 sd=0
VR_m156 nref m156r 0
XO_m156 m156o m156r Vdd Vdd pfet_03v3 L=3.565u W=1.037u nf=1 ad='int((nf+1)/2) * W/nf * 0.18u' as='int((nf+2)/2) * W/nf * 0.18u' pd='2*int((nf+1)/2) * (W/nf + 0.18u)' ps='2*int((nf+2)/2) * (W/nf + 0.18u)' nrd='0.18u / W' nrs='0.18u / W' sa=0 sb=0 sd=0
VO_m156 m156o Vmem 0
XR_m157 m157r m157r Vdd Vdd pfet_03v3 L=1.911u W=2.427u nf=1 ad='int((nf+1)/2) * W/nf * 0.18u' as='int((nf+2)/2) * W/nf * 0.18u' pd='2*int((nf+1)/2) * (W/nf + 0.18u)' ps='2*int((nf+2)/2) * (W/nf + 0.18u)' nrd='0.18u / W' nrs='0.18u / W' sa=0 sb=0 sd=0
VR_m157 nref m157r 0
XO_m157 m157o m157r Vdd Vdd pfet_03v3 L=1.542u W=0.649u nf=1 ad='int((nf+1)/2) * W/nf * 0.18u' as='int((nf+2)/2) * W/nf * 0.18u' pd='2*int((nf+1)/2) * (W/nf + 0.18u)' ps='2*int((nf+2)/2) * (W/nf + 0.18u)' nrd='0.18u / W' nrs='0.18u / W' sa=0 sb=0 sd=0
VO_m157 m157o Vmem 0
XR_m158 m158r m158r Vdd Vdd pfet_03v3 L=0.736u W=0.936u nf=1 ad='int((nf+1)/2) * W/nf * 0.18u' as='int((nf+2)/2) * W/nf * 0.18u' pd='2*int((nf+1)/2) * (W/nf + 0.18u)' ps='2*int((nf+2)/2) * (W/nf + 0.18u)' nrd='0.18u / W' nrs='0.18u / W' sa=0 sb=0 sd=0
VR_m158 nref m158r 0
XO_m158 m158o m158r Vdd Vdd pfet_03v3 L=0.994u W=0.227u nf=1 ad='int((nf+1)/2) * W/nf * 0.18u' as='int((nf+2)/2) * W/nf * 0.18u' pd='2*int((nf+1)/2) * (W/nf + 0.18u)' ps='2*int((nf+2)/2) * (W/nf + 0.18u)' nrd='0.18u / W' nrs='0.18u / W' sa=0 sb=0 sd=0
VO_m158 m158o Vmem 0
XR_m159 m159r m159r Vdd Vdd pfet_03v3 L=2.754u W=1.177u nf=1 ad='int((nf+1)/2) * W/nf * 0.18u' as='int((nf+2)/2) * W/nf * 0.18u' pd='2*int((nf+1)/2) * (W/nf + 0.18u)' ps='2*int((nf+2)/2) * (W/nf + 0.18u)' nrd='0.18u / W' nrs='0.18u / W' sa=0 sb=0 sd=0
VR_m159 nref m159r 0
XO_m159 m159o m159r Vdd Vdd pfet_03v3 L=1.827u W=0.651u nf=1 ad='int((nf+1)/2) * W/nf * 0.18u' as='int((nf+2)/2) * W/nf * 0.18u' pd='2*int((nf+1)/2) * (W/nf + 0.18u)' ps='2*int((nf+2)/2) * (W/nf + 0.18u)' nrd='0.18u / W' nrs='0.18u / W' sa=0 sb=0 sd=0
VO_m159 m159o Vmem 0
XR_m160 m160r m160r Vdd Vdd pfet_03v3 L=0.647u W=1.157u nf=1 ad='int((nf+1)/2) * W/nf * 0.18u' as='int((nf+2)/2) * W/nf * 0.18u' pd='2*int((nf+1)/2) * (W/nf + 0.18u)' ps='2*int((nf+2)/2) * (W/nf + 0.18u)' nrd='0.18u / W' nrs='0.18u / W' sa=0 sb=0 sd=0
VR_m160 nref m160r 0
XO_m160 m160o m160r Vdd Vdd pfet_03v3 L=3.858u W=2.305u nf=1 ad='int((nf+1)/2) * W/nf * 0.18u' as='int((nf+2)/2) * W/nf * 0.18u' pd='2*int((nf+1)/2) * (W/nf + 0.18u)' ps='2*int((nf+2)/2) * (W/nf + 0.18u)' nrd='0.18u / W' nrs='0.18u / W' sa=0 sb=0 sd=0
VO_m160 m160o Vmem 0
XR_m161 m161r m161r Vdd Vdd pfet_03v3 L=0.696u W=3.958u nf=1 ad='int((nf+1)/2) * W/nf * 0.18u' as='int((nf+2)/2) * W/nf * 0.18u' pd='2*int((nf+1)/2) * (W/nf + 0.18u)' ps='2*int((nf+2)/2) * (W/nf + 0.18u)' nrd='0.18u / W' nrs='0.18u / W' sa=0 sb=0 sd=0
VR_m161 nref m161r 0
XO_m161 m161o m161r Vdd Vdd pfet_03v3 L=1.581u W=0.665u nf=1 ad='int((nf+1)/2) * W/nf * 0.18u' as='int((nf+2)/2) * W/nf * 0.18u' pd='2*int((nf+1)/2) * (W/nf + 0.18u)' ps='2*int((nf+2)/2) * (W/nf + 0.18u)' nrd='0.18u / W' nrs='0.18u / W' sa=0 sb=0 sd=0
VO_m161 m161o Vmem 0
XR_m162 m162r m162r Vdd Vdd pfet_03v3 L=2.533u W=0.354u nf=1 ad='int((nf+1)/2) * W/nf * 0.18u' as='int((nf+2)/2) * W/nf * 0.18u' pd='2*int((nf+1)/2) * (W/nf + 0.18u)' ps='2*int((nf+2)/2) * (W/nf + 0.18u)' nrd='0.18u / W' nrs='0.18u / W' sa=0 sb=0 sd=0
VR_m162 nref m162r 0
XO_m162 m162o m162r Vdd Vdd pfet_03v3 L=2.178u W=0.378u nf=1 ad='int((nf+1)/2) * W/nf * 0.18u' as='int((nf+2)/2) * W/nf * 0.18u' pd='2*int((nf+1)/2) * (W/nf + 0.18u)' ps='2*int((nf+2)/2) * (W/nf + 0.18u)' nrd='0.18u / W' nrs='0.18u / W' sa=0 sb=0 sd=0
VO_m162 m162o Vmem 0
XR_m163 m163r m163r Vdd Vdd pfet_03v3 L=1.159u W=1.755u nf=1 ad='int((nf+1)/2) * W/nf * 0.18u' as='int((nf+2)/2) * W/nf * 0.18u' pd='2*int((nf+1)/2) * (W/nf + 0.18u)' ps='2*int((nf+2)/2) * (W/nf + 0.18u)' nrd='0.18u / W' nrs='0.18u / W' sa=0 sb=0 sd=0
VR_m163 nref m163r 0
XO_m163 m163o m163r Vdd Vdd pfet_03v3 L=1.272u W=0.349u nf=1 ad='int((nf+1)/2) * W/nf * 0.18u' as='int((nf+2)/2) * W/nf * 0.18u' pd='2*int((nf+1)/2) * (W/nf + 0.18u)' ps='2*int((nf+2)/2) * (W/nf + 0.18u)' nrd='0.18u / W' nrs='0.18u / W' sa=0 sb=0 sd=0
VO_m163 m163o Vmem 0
XR_m164 m164r m164r Vdd Vdd pfet_03v3 L=1.199u W=0.971u nf=1 ad='int((nf+1)/2) * W/nf * 0.18u' as='int((nf+2)/2) * W/nf * 0.18u' pd='2*int((nf+1)/2) * (W/nf + 0.18u)' ps='2*int((nf+2)/2) * (W/nf + 0.18u)' nrd='0.18u / W' nrs='0.18u / W' sa=0 sb=0 sd=0
VR_m164 nref m164r 0
XO_m164 m164o m164r Vdd Vdd pfet_03v3 L=0.318u W=2.772u nf=1 ad='int((nf+1)/2) * W/nf * 0.18u' as='int((nf+2)/2) * W/nf * 0.18u' pd='2*int((nf+1)/2) * (W/nf + 0.18u)' ps='2*int((nf+2)/2) * (W/nf + 0.18u)' nrd='0.18u / W' nrs='0.18u / W' sa=0 sb=0 sd=0
VO_m164 m164o Vmem 0
XR_m165 m165r m165r Vdd Vdd pfet_03v3 L=0.607u W=0.261u nf=1 ad='int((nf+1)/2) * W/nf * 0.18u' as='int((nf+2)/2) * W/nf * 0.18u' pd='2*int((nf+1)/2) * (W/nf + 0.18u)' ps='2*int((nf+2)/2) * (W/nf + 0.18u)' nrd='0.18u / W' nrs='0.18u / W' sa=0 sb=0 sd=0
VR_m165 nref m165r 0
XO_m165 m165o m165r Vdd Vdd pfet_03v3 L=6.664u W=2.782u nf=1 ad='int((nf+1)/2) * W/nf * 0.18u' as='int((nf+2)/2) * W/nf * 0.18u' pd='2*int((nf+1)/2) * (W/nf + 0.18u)' ps='2*int((nf+2)/2) * (W/nf + 0.18u)' nrd='0.18u / W' nrs='0.18u / W' sa=0 sb=0 sd=0
VO_m165 m165o Vmem 0
XR_m166 m166r m166r Vdd Vdd pfet_03v3 L=1.505u W=0.272u nf=1 ad='int((nf+1)/2) * W/nf * 0.18u' as='int((nf+2)/2) * W/nf * 0.18u' pd='2*int((nf+1)/2) * (W/nf + 0.18u)' ps='2*int((nf+2)/2) * (W/nf + 0.18u)' nrd='0.18u / W' nrs='0.18u / W' sa=0 sb=0 sd=0
VR_m166 nref m166r 0
XO_m166 m166o m166r Vdd Vdd pfet_03v3 L=0.285u W=3.932u nf=1 ad='int((nf+1)/2) * W/nf * 0.18u' as='int((nf+2)/2) * W/nf * 0.18u' pd='2*int((nf+1)/2) * (W/nf + 0.18u)' ps='2*int((nf+2)/2) * (W/nf + 0.18u)' nrd='0.18u / W' nrs='0.18u / W' sa=0 sb=0 sd=0
VO_m166 m166o Vmem 0
XR_m167 m167r m167r Vdd Vdd pfet_03v3 L=0.861u W=0.963u nf=1 ad='int((nf+1)/2) * W/nf * 0.18u' as='int((nf+2)/2) * W/nf * 0.18u' pd='2*int((nf+1)/2) * (W/nf + 0.18u)' ps='2*int((nf+2)/2) * (W/nf + 0.18u)' nrd='0.18u / W' nrs='0.18u / W' sa=0 sb=0 sd=0
VR_m167 nref m167r 0
XO_m167 m167o m167r Vdd Vdd pfet_03v3 L=1.767u W=1.471u nf=1 ad='int((nf+1)/2) * W/nf * 0.18u' as='int((nf+2)/2) * W/nf * 0.18u' pd='2*int((nf+1)/2) * (W/nf + 0.18u)' ps='2*int((nf+2)/2) * (W/nf + 0.18u)' nrd='0.18u / W' nrs='0.18u / W' sa=0 sb=0 sd=0
VO_m167 m167o Vmem 0
XR_m168 m168r m168r Vdd Vdd pfet_03v3 L=0.587u W=0.262u nf=1 ad='int((nf+1)/2) * W/nf * 0.18u' as='int((nf+2)/2) * W/nf * 0.18u' pd='2*int((nf+1)/2) * (W/nf + 0.18u)' ps='2*int((nf+2)/2) * (W/nf + 0.18u)' nrd='0.18u / W' nrs='0.18u / W' sa=0 sb=0 sd=0
VR_m168 nref m168r 0
XO_m168 m168o m168r Vdd Vdd pfet_03v3 L=2.355u W=0.496u nf=1 ad='int((nf+1)/2) * W/nf * 0.18u' as='int((nf+2)/2) * W/nf * 0.18u' pd='2*int((nf+1)/2) * (W/nf + 0.18u)' ps='2*int((nf+2)/2) * (W/nf + 0.18u)' nrd='0.18u / W' nrs='0.18u / W' sa=0 sb=0 sd=0
VO_m168 m168o Vmem 0
XR_m169 m169r m169r Vdd Vdd pfet_03v3 L=0.907u W=0.304u nf=1 ad='int((nf+1)/2) * W/nf * 0.18u' as='int((nf+2)/2) * W/nf * 0.18u' pd='2*int((nf+1)/2) * (W/nf + 0.18u)' ps='2*int((nf+2)/2) * (W/nf + 0.18u)' nrd='0.18u / W' nrs='0.18u / W' sa=0 sb=0 sd=0
VR_m169 nref m169r 0
XO_m169 m169o m169r Vdd Vdd pfet_03v3 L=0.798u W=0.51u nf=1 ad='int((nf+1)/2) * W/nf * 0.18u' as='int((nf+2)/2) * W/nf * 0.18u' pd='2*int((nf+1)/2) * (W/nf + 0.18u)' ps='2*int((nf+2)/2) * (W/nf + 0.18u)' nrd='0.18u / W' nrs='0.18u / W' sa=0 sb=0 sd=0
VO_m169 m169o Vmem 0
XR_m170 m170r m170r Vdd Vdd pfet_03v3 L=1.549u W=1.038u nf=1 ad='int((nf+1)/2) * W/nf * 0.18u' as='int((nf+2)/2) * W/nf * 0.18u' pd='2*int((nf+1)/2) * (W/nf + 0.18u)' ps='2*int((nf+2)/2) * (W/nf + 0.18u)' nrd='0.18u / W' nrs='0.18u / W' sa=0 sb=0 sd=0
VR_m170 nref m170r 0
XO_m170 m170o m170r Vdd Vdd pfet_03v3 L=1.631u W=0.957u nf=1 ad='int((nf+1)/2) * W/nf * 0.18u' as='int((nf+2)/2) * W/nf * 0.18u' pd='2*int((nf+1)/2) * (W/nf + 0.18u)' ps='2*int((nf+2)/2) * (W/nf + 0.18u)' nrd='0.18u / W' nrs='0.18u / W' sa=0 sb=0 sd=0
VO_m170 m170o Vmem 0
XR_m171 m171r m171r Vdd Vdd pfet_03v3 L=2.768u W=2.797u nf=1 ad='int((nf+1)/2) * W/nf * 0.18u' as='int((nf+2)/2) * W/nf * 0.18u' pd='2*int((nf+1)/2) * (W/nf + 0.18u)' ps='2*int((nf+2)/2) * (W/nf + 0.18u)' nrd='0.18u / W' nrs='0.18u / W' sa=0 sb=0 sd=0
VR_m171 nref m171r 0
XO_m171 m171o m171r Vdd Vdd pfet_03v3 L=5.911u W=3.886u nf=1 ad='int((nf+1)/2) * W/nf * 0.18u' as='int((nf+2)/2) * W/nf * 0.18u' pd='2*int((nf+1)/2) * (W/nf + 0.18u)' ps='2*int((nf+2)/2) * (W/nf + 0.18u)' nrd='0.18u / W' nrs='0.18u / W' sa=0 sb=0 sd=0
VO_m171 m171o Vmem 0
XR_m172 m172r m172r Vdd Vdd pfet_03v3 L=3.863u W=1.708u nf=1 ad='int((nf+1)/2) * W/nf * 0.18u' as='int((nf+2)/2) * W/nf * 0.18u' pd='2*int((nf+1)/2) * (W/nf + 0.18u)' ps='2*int((nf+2)/2) * (W/nf + 0.18u)' nrd='0.18u / W' nrs='0.18u / W' sa=0 sb=0 sd=0
VR_m172 nref m172r 0
XO_m172 m172o m172r Vdd Vdd pfet_03v3 L=2.235u W=3.845u nf=1 ad='int((nf+1)/2) * W/nf * 0.18u' as='int((nf+2)/2) * W/nf * 0.18u' pd='2*int((nf+1)/2) * (W/nf + 0.18u)' ps='2*int((nf+2)/2) * (W/nf + 0.18u)' nrd='0.18u / W' nrs='0.18u / W' sa=0 sb=0 sd=0
VO_m172 m172o Vmem 0
XR_m173 m173r m173r Vdd Vdd pfet_03v3 L=1.234u W=0.504u nf=1 ad='int((nf+1)/2) * W/nf * 0.18u' as='int((nf+2)/2) * W/nf * 0.18u' pd='2*int((nf+1)/2) * (W/nf + 0.18u)' ps='2*int((nf+2)/2) * (W/nf + 0.18u)' nrd='0.18u / W' nrs='0.18u / W' sa=0 sb=0 sd=0
VR_m173 nref m173r 0
XO_m173 m173o m173r Vdd Vdd pfet_03v3 L=0.285u W=1.201u nf=1 ad='int((nf+1)/2) * W/nf * 0.18u' as='int((nf+2)/2) * W/nf * 0.18u' pd='2*int((nf+1)/2) * (W/nf + 0.18u)' ps='2*int((nf+2)/2) * (W/nf + 0.18u)' nrd='0.18u / W' nrs='0.18u / W' sa=0 sb=0 sd=0
VO_m173 m173o Vmem 0
XR_m174 m174r m174r Vdd Vdd pfet_03v3 L=0.424u W=1.252u nf=1 ad='int((nf+1)/2) * W/nf * 0.18u' as='int((nf+2)/2) * W/nf * 0.18u' pd='2*int((nf+1)/2) * (W/nf + 0.18u)' ps='2*int((nf+2)/2) * (W/nf + 0.18u)' nrd='0.18u / W' nrs='0.18u / W' sa=0 sb=0 sd=0
VR_m174 nref m174r 0
XO_m174 m174o m174r Vdd Vdd pfet_03v3 L=2.149u W=2.052u nf=1 ad='int((nf+1)/2) * W/nf * 0.18u' as='int((nf+2)/2) * W/nf * 0.18u' pd='2*int((nf+1)/2) * (W/nf + 0.18u)' ps='2*int((nf+2)/2) * (W/nf + 0.18u)' nrd='0.18u / W' nrs='0.18u / W' sa=0 sb=0 sd=0
VO_m174 m174o Vmem 0
XR_m175 m175r m175r Vdd Vdd pfet_03v3 L=0.308u W=3.815u nf=1 ad='int((nf+1)/2) * W/nf * 0.18u' as='int((nf+2)/2) * W/nf * 0.18u' pd='2*int((nf+1)/2) * (W/nf + 0.18u)' ps='2*int((nf+2)/2) * (W/nf + 0.18u)' nrd='0.18u / W' nrs='0.18u / W' sa=0 sb=0 sd=0
VR_m175 nref m175r 0
XO_m175 m175o m175r Vdd Vdd pfet_03v3 L=1.049u W=0.841u nf=1 ad='int((nf+1)/2) * W/nf * 0.18u' as='int((nf+2)/2) * W/nf * 0.18u' pd='2*int((nf+1)/2) * (W/nf + 0.18u)' ps='2*int((nf+2)/2) * (W/nf + 0.18u)' nrd='0.18u / W' nrs='0.18u / W' sa=0 sb=0 sd=0
VO_m175 m175o Vmem 0
XR_m176 m176r m176r Vdd Vdd pfet_03v3 L=3.167u W=1.879u nf=1 ad='int((nf+1)/2) * W/nf * 0.18u' as='int((nf+2)/2) * W/nf * 0.18u' pd='2*int((nf+1)/2) * (W/nf + 0.18u)' ps='2*int((nf+2)/2) * (W/nf + 0.18u)' nrd='0.18u / W' nrs='0.18u / W' sa=0 sb=0 sd=0
VR_m176 nref m176r 0
XO_m176 m176o m176r Vdd Vdd pfet_03v3 L=1.943u W=0.801u nf=1 ad='int((nf+1)/2) * W/nf * 0.18u' as='int((nf+2)/2) * W/nf * 0.18u' pd='2*int((nf+1)/2) * (W/nf + 0.18u)' ps='2*int((nf+2)/2) * (W/nf + 0.18u)' nrd='0.18u / W' nrs='0.18u / W' sa=0 sb=0 sd=0
VO_m176 m176o Vmem 0
XR_m177 m177r m177r Vdd Vdd pfet_03v3 L=0.385u W=1.656u nf=1 ad='int((nf+1)/2) * W/nf * 0.18u' as='int((nf+2)/2) * W/nf * 0.18u' pd='2*int((nf+1)/2) * (W/nf + 0.18u)' ps='2*int((nf+2)/2) * (W/nf + 0.18u)' nrd='0.18u / W' nrs='0.18u / W' sa=0 sb=0 sd=0
VR_m177 nref m177r 0
XO_m177 m177o m177r Vdd Vdd pfet_03v3 L=6.981u W=3.117u nf=1 ad='int((nf+1)/2) * W/nf * 0.18u' as='int((nf+2)/2) * W/nf * 0.18u' pd='2*int((nf+1)/2) * (W/nf + 0.18u)' ps='2*int((nf+2)/2) * (W/nf + 0.18u)' nrd='0.18u / W' nrs='0.18u / W' sa=0 sb=0 sd=0
VO_m177 m177o Vmem 0
XR_m178 m178r m178r Vdd Vdd pfet_03v3 L=3.091u W=0.788u nf=1 ad='int((nf+1)/2) * W/nf * 0.18u' as='int((nf+2)/2) * W/nf * 0.18u' pd='2*int((nf+1)/2) * (W/nf + 0.18u)' ps='2*int((nf+2)/2) * (W/nf + 0.18u)' nrd='0.18u / W' nrs='0.18u / W' sa=0 sb=0 sd=0
VR_m178 nref m178r 0
XO_m178 m178o m178r Vdd Vdd pfet_03v3 L=0.289u W=0.576u nf=1 ad='int((nf+1)/2) * W/nf * 0.18u' as='int((nf+2)/2) * W/nf * 0.18u' pd='2*int((nf+1)/2) * (W/nf + 0.18u)' ps='2*int((nf+2)/2) * (W/nf + 0.18u)' nrd='0.18u / W' nrs='0.18u / W' sa=0 sb=0 sd=0
VO_m178 m178o Vmem 0
XR_m179 m179r m179r Vdd Vdd pfet_03v3 L=0.552u W=0.617u nf=1 ad='int((nf+1)/2) * W/nf * 0.18u' as='int((nf+2)/2) * W/nf * 0.18u' pd='2*int((nf+1)/2) * (W/nf + 0.18u)' ps='2*int((nf+2)/2) * (W/nf + 0.18u)' nrd='0.18u / W' nrs='0.18u / W' sa=0 sb=0 sd=0
VR_m179 nref m179r 0
XO_m179 m179o m179r Vdd Vdd pfet_03v3 L=0.455u W=0.234u nf=1 ad='int((nf+1)/2) * W/nf * 0.18u' as='int((nf+2)/2) * W/nf * 0.18u' pd='2*int((nf+1)/2) * (W/nf + 0.18u)' ps='2*int((nf+2)/2) * (W/nf + 0.18u)' nrd='0.18u / W' nrs='0.18u / W' sa=0 sb=0 sd=0
VO_m179 m179o Vmem 0
XR_m180 m180r m180r Vdd Vdd pfet_03v3 L=0.605u W=2.164u nf=1 ad='int((nf+1)/2) * W/nf * 0.18u' as='int((nf+2)/2) * W/nf * 0.18u' pd='2*int((nf+1)/2) * (W/nf + 0.18u)' ps='2*int((nf+2)/2) * (W/nf + 0.18u)' nrd='0.18u / W' nrs='0.18u / W' sa=0 sb=0 sd=0
VR_m180 nref m180r 0
XO_m180 m180o m180r Vdd Vdd pfet_03v3 L=0.654u W=1.705u nf=1 ad='int((nf+1)/2) * W/nf * 0.18u' as='int((nf+2)/2) * W/nf * 0.18u' pd='2*int((nf+1)/2) * (W/nf + 0.18u)' ps='2*int((nf+2)/2) * (W/nf + 0.18u)' nrd='0.18u / W' nrs='0.18u / W' sa=0 sb=0 sd=0
VO_m180 m180o Vmem 0
XR_m181 m181r m181r Vdd Vdd pfet_03v3 L=3.622u W=0.345u nf=1 ad='int((nf+1)/2) * W/nf * 0.18u' as='int((nf+2)/2) * W/nf * 0.18u' pd='2*int((nf+1)/2) * (W/nf + 0.18u)' ps='2*int((nf+2)/2) * (W/nf + 0.18u)' nrd='0.18u / W' nrs='0.18u / W' sa=0 sb=0 sd=0
VR_m181 nref m181r 0
XO_m181 m181o m181r Vdd Vdd pfet_03v3 L=0.848u W=3.948u nf=1 ad='int((nf+1)/2) * W/nf * 0.18u' as='int((nf+2)/2) * W/nf * 0.18u' pd='2*int((nf+1)/2) * (W/nf + 0.18u)' ps='2*int((nf+2)/2) * (W/nf + 0.18u)' nrd='0.18u / W' nrs='0.18u / W' sa=0 sb=0 sd=0
VO_m181 m181o Vmem 0
XR_m182 m182r m182r Vdd Vdd pfet_03v3 L=3.228u W=1.935u nf=1 ad='int((nf+1)/2) * W/nf * 0.18u' as='int((nf+2)/2) * W/nf * 0.18u' pd='2*int((nf+1)/2) * (W/nf + 0.18u)' ps='2*int((nf+2)/2) * (W/nf + 0.18u)' nrd='0.18u / W' nrs='0.18u / W' sa=0 sb=0 sd=0
VR_m182 nref m182r 0
XO_m182 m182o m182r Vdd Vdd pfet_03v3 L=3.881u W=3.849u nf=1 ad='int((nf+1)/2) * W/nf * 0.18u' as='int((nf+2)/2) * W/nf * 0.18u' pd='2*int((nf+1)/2) * (W/nf + 0.18u)' ps='2*int((nf+2)/2) * (W/nf + 0.18u)' nrd='0.18u / W' nrs='0.18u / W' sa=0 sb=0 sd=0
VO_m182 m182o Vmem 0
XR_m183 m183r m183r Vdd Vdd pfet_03v3 L=2.714u W=2.228u nf=1 ad='int((nf+1)/2) * W/nf * 0.18u' as='int((nf+2)/2) * W/nf * 0.18u' pd='2*int((nf+1)/2) * (W/nf + 0.18u)' ps='2*int((nf+2)/2) * (W/nf + 0.18u)' nrd='0.18u / W' nrs='0.18u / W' sa=0 sb=0 sd=0
VR_m183 nref m183r 0
XO_m183 m183o m183r Vdd Vdd pfet_03v3 L=5.18u W=1.714u nf=1 ad='int((nf+1)/2) * W/nf * 0.18u' as='int((nf+2)/2) * W/nf * 0.18u' pd='2*int((nf+1)/2) * (W/nf + 0.18u)' ps='2*int((nf+2)/2) * (W/nf + 0.18u)' nrd='0.18u / W' nrs='0.18u / W' sa=0 sb=0 sd=0
VO_m183 m183o Vmem 0
XR_m184 m184r m184r Vdd Vdd pfet_03v3 L=1.302u W=3.044u nf=1 ad='int((nf+1)/2) * W/nf * 0.18u' as='int((nf+2)/2) * W/nf * 0.18u' pd='2*int((nf+1)/2) * (W/nf + 0.18u)' ps='2*int((nf+2)/2) * (W/nf + 0.18u)' nrd='0.18u / W' nrs='0.18u / W' sa=0 sb=0 sd=0
VR_m184 nref m184r 0
XO_m184 m184o m184r Vdd Vdd pfet_03v3 L=1.557u W=3.308u nf=1 ad='int((nf+1)/2) * W/nf * 0.18u' as='int((nf+2)/2) * W/nf * 0.18u' pd='2*int((nf+1)/2) * (W/nf + 0.18u)' ps='2*int((nf+2)/2) * (W/nf + 0.18u)' nrd='0.18u / W' nrs='0.18u / W' sa=0 sb=0 sd=0
VO_m184 m184o Vmem 0
XR_m185 m185r m185r Vdd Vdd pfet_03v3 L=1.122u W=0.845u nf=1 ad='int((nf+1)/2) * W/nf * 0.18u' as='int((nf+2)/2) * W/nf * 0.18u' pd='2*int((nf+1)/2) * (W/nf + 0.18u)' ps='2*int((nf+2)/2) * (W/nf + 0.18u)' nrd='0.18u / W' nrs='0.18u / W' sa=0 sb=0 sd=0
VR_m185 nref m185r 0
XO_m185 m185o m185r Vdd Vdd pfet_03v3 L=7.358u W=1.592u nf=1 ad='int((nf+1)/2) * W/nf * 0.18u' as='int((nf+2)/2) * W/nf * 0.18u' pd='2*int((nf+1)/2) * (W/nf + 0.18u)' ps='2*int((nf+2)/2) * (W/nf + 0.18u)' nrd='0.18u / W' nrs='0.18u / W' sa=0 sb=0 sd=0
VO_m185 m185o Vmem 0
XR_m186 m186r m186r Vdd Vdd pfet_03v3 L=1.939u W=2.562u nf=1 ad='int((nf+1)/2) * W/nf * 0.18u' as='int((nf+2)/2) * W/nf * 0.18u' pd='2*int((nf+1)/2) * (W/nf + 0.18u)' ps='2*int((nf+2)/2) * (W/nf + 0.18u)' nrd='0.18u / W' nrs='0.18u / W' sa=0 sb=0 sd=0
VR_m186 nref m186r 0
XO_m186 m186o m186r Vdd Vdd pfet_03v3 L=0.776u W=0.568u nf=1 ad='int((nf+1)/2) * W/nf * 0.18u' as='int((nf+2)/2) * W/nf * 0.18u' pd='2*int((nf+1)/2) * (W/nf + 0.18u)' ps='2*int((nf+2)/2) * (W/nf + 0.18u)' nrd='0.18u / W' nrs='0.18u / W' sa=0 sb=0 sd=0
VO_m186 m186o Vmem 0
XR_m187 m187r m187r Vdd Vdd pfet_03v3 L=2.131u W=0.748u nf=1 ad='int((nf+1)/2) * W/nf * 0.18u' as='int((nf+2)/2) * W/nf * 0.18u' pd='2*int((nf+1)/2) * (W/nf + 0.18u)' ps='2*int((nf+2)/2) * (W/nf + 0.18u)' nrd='0.18u / W' nrs='0.18u / W' sa=0 sb=0 sd=0
VR_m187 nref m187r 0
XO_m187 m187o m187r Vdd Vdd pfet_03v3 L=2.41u W=0.717u nf=1 ad='int((nf+1)/2) * W/nf * 0.18u' as='int((nf+2)/2) * W/nf * 0.18u' pd='2*int((nf+1)/2) * (W/nf + 0.18u)' ps='2*int((nf+2)/2) * (W/nf + 0.18u)' nrd='0.18u / W' nrs='0.18u / W' sa=0 sb=0 sd=0
VO_m187 m187o Vmem 0
XR_m188 m188r m188r Vdd Vdd pfet_03v3 L=0.883u W=3.743u nf=1 ad='int((nf+1)/2) * W/nf * 0.18u' as='int((nf+2)/2) * W/nf * 0.18u' pd='2*int((nf+1)/2) * (W/nf + 0.18u)' ps='2*int((nf+2)/2) * (W/nf + 0.18u)' nrd='0.18u / W' nrs='0.18u / W' sa=0 sb=0 sd=0
VR_m188 nref m188r 0
XO_m188 m188o m188r Vdd Vdd pfet_03v3 L=1.524u W=2.972u nf=1 ad='int((nf+1)/2) * W/nf * 0.18u' as='int((nf+2)/2) * W/nf * 0.18u' pd='2*int((nf+1)/2) * (W/nf + 0.18u)' ps='2*int((nf+2)/2) * (W/nf + 0.18u)' nrd='0.18u / W' nrs='0.18u / W' sa=0 sb=0 sd=0
VO_m188 m188o Vmem 0
XR_m189 m189r m189r Vdd Vdd pfet_03v3 L=2.956u W=0.307u nf=1 ad='int((nf+1)/2) * W/nf * 0.18u' as='int((nf+2)/2) * W/nf * 0.18u' pd='2*int((nf+1)/2) * (W/nf + 0.18u)' ps='2*int((nf+2)/2) * (W/nf + 0.18u)' nrd='0.18u / W' nrs='0.18u / W' sa=0 sb=0 sd=0
VR_m189 nref m189r 0
XO_m189 m189o m189r Vdd Vdd pfet_03v3 L=2.284u W=2.764u nf=1 ad='int((nf+1)/2) * W/nf * 0.18u' as='int((nf+2)/2) * W/nf * 0.18u' pd='2*int((nf+1)/2) * (W/nf + 0.18u)' ps='2*int((nf+2)/2) * (W/nf + 0.18u)' nrd='0.18u / W' nrs='0.18u / W' sa=0 sb=0 sd=0
VO_m189 m189o Vmem 0
XR_m190 m190r m190r Vdd Vdd pfet_03v3 L=0.688u W=0.958u nf=1 ad='int((nf+1)/2) * W/nf * 0.18u' as='int((nf+2)/2) * W/nf * 0.18u' pd='2*int((nf+1)/2) * (W/nf + 0.18u)' ps='2*int((nf+2)/2) * (W/nf + 0.18u)' nrd='0.18u / W' nrs='0.18u / W' sa=0 sb=0 sd=0
VR_m190 nref m190r 0
XO_m190 m190o m190r Vdd Vdd pfet_03v3 L=5.053u W=3.688u nf=1 ad='int((nf+1)/2) * W/nf * 0.18u' as='int((nf+2)/2) * W/nf * 0.18u' pd='2*int((nf+1)/2) * (W/nf + 0.18u)' ps='2*int((nf+2)/2) * (W/nf + 0.18u)' nrd='0.18u / W' nrs='0.18u / W' sa=0 sb=0 sd=0
VO_m190 m190o Vmem 0
XR_m191 m191r m191r Vdd Vdd pfet_03v3 L=2.188u W=0.384u nf=1 ad='int((nf+1)/2) * W/nf * 0.18u' as='int((nf+2)/2) * W/nf * 0.18u' pd='2*int((nf+1)/2) * (W/nf + 0.18u)' ps='2*int((nf+2)/2) * (W/nf + 0.18u)' nrd='0.18u / W' nrs='0.18u / W' sa=0 sb=0 sd=0
VR_m191 nref m191r 0
XO_m191 m191o m191r Vdd Vdd pfet_03v3 L=0.962u W=0.475u nf=1 ad='int((nf+1)/2) * W/nf * 0.18u' as='int((nf+2)/2) * W/nf * 0.18u' pd='2*int((nf+1)/2) * (W/nf + 0.18u)' ps='2*int((nf+2)/2) * (W/nf + 0.18u)' nrd='0.18u / W' nrs='0.18u / W' sa=0 sb=0 sd=0
VO_m191 m191o Vmem 0
XR_m192 m192r m192r Vdd Vdd pfet_03v3 L=0.507u W=0.403u nf=1 ad='int((nf+1)/2) * W/nf * 0.18u' as='int((nf+2)/2) * W/nf * 0.18u' pd='2*int((nf+1)/2) * (W/nf + 0.18u)' ps='2*int((nf+2)/2) * (W/nf + 0.18u)' nrd='0.18u / W' nrs='0.18u / W' sa=0 sb=0 sd=0
VR_m192 nref m192r 0
XO_m192 m192o m192r Vdd Vdd pfet_03v3 L=3.3u W=2.223u nf=1 ad='int((nf+1)/2) * W/nf * 0.18u' as='int((nf+2)/2) * W/nf * 0.18u' pd='2*int((nf+1)/2) * (W/nf + 0.18u)' ps='2*int((nf+2)/2) * (W/nf + 0.18u)' nrd='0.18u / W' nrs='0.18u / W' sa=0 sb=0 sd=0
VO_m192 m192o Vmem 0
XR_m193 m193r m193r Vdd Vdd pfet_03v3 L=1.553u W=0.671u nf=1 ad='int((nf+1)/2) * W/nf * 0.18u' as='int((nf+2)/2) * W/nf * 0.18u' pd='2*int((nf+1)/2) * (W/nf + 0.18u)' ps='2*int((nf+2)/2) * (W/nf + 0.18u)' nrd='0.18u / W' nrs='0.18u / W' sa=0 sb=0 sd=0
VR_m193 nref m193r 0
XO_m193 m193o m193r Vdd Vdd pfet_03v3 L=0.846u W=1.062u nf=1 ad='int((nf+1)/2) * W/nf * 0.18u' as='int((nf+2)/2) * W/nf * 0.18u' pd='2*int((nf+1)/2) * (W/nf + 0.18u)' ps='2*int((nf+2)/2) * (W/nf + 0.18u)' nrd='0.18u / W' nrs='0.18u / W' sa=0 sb=0 sd=0
VO_m193 m193o Vmem 0
XR_m194 m194r m194r Vdd Vdd pfet_03v3 L=0.635u W=0.648u nf=1 ad='int((nf+1)/2) * W/nf * 0.18u' as='int((nf+2)/2) * W/nf * 0.18u' pd='2*int((nf+1)/2) * (W/nf + 0.18u)' ps='2*int((nf+2)/2) * (W/nf + 0.18u)' nrd='0.18u / W' nrs='0.18u / W' sa=0 sb=0 sd=0
VR_m194 nref m194r 0
XO_m194 m194o m194r Vdd Vdd pfet_03v3 L=5.661u W=1.525u nf=1 ad='int((nf+1)/2) * W/nf * 0.18u' as='int((nf+2)/2) * W/nf * 0.18u' pd='2*int((nf+1)/2) * (W/nf + 0.18u)' ps='2*int((nf+2)/2) * (W/nf + 0.18u)' nrd='0.18u / W' nrs='0.18u / W' sa=0 sb=0 sd=0
VO_m194 m194o Vmem 0
XR_m195 m195r m195r Vdd Vdd pfet_03v3 L=1.68u W=1.308u nf=1 ad='int((nf+1)/2) * W/nf * 0.18u' as='int((nf+2)/2) * W/nf * 0.18u' pd='2*int((nf+1)/2) * (W/nf + 0.18u)' ps='2*int((nf+2)/2) * (W/nf + 0.18u)' nrd='0.18u / W' nrs='0.18u / W' sa=0 sb=0 sd=0
VR_m195 nref m195r 0
XO_m195 m195o m195r Vdd Vdd pfet_03v3 L=0.971u W=1.39u nf=1 ad='int((nf+1)/2) * W/nf * 0.18u' as='int((nf+2)/2) * W/nf * 0.18u' pd='2*int((nf+1)/2) * (W/nf + 0.18u)' ps='2*int((nf+2)/2) * (W/nf + 0.18u)' nrd='0.18u / W' nrs='0.18u / W' sa=0 sb=0 sd=0
VO_m195 m195o Vmem 0
XR_m196 m196r m196r Vdd Vdd pfet_03v3 L=0.378u W=0.846u nf=1 ad='int((nf+1)/2) * W/nf * 0.18u' as='int((nf+2)/2) * W/nf * 0.18u' pd='2*int((nf+1)/2) * (W/nf + 0.18u)' ps='2*int((nf+2)/2) * (W/nf + 0.18u)' nrd='0.18u / W' nrs='0.18u / W' sa=0 sb=0 sd=0
VR_m196 nref m196r 0
XO_m196 m196o m196r Vdd Vdd pfet_03v3 L=1.721u W=0.296u nf=1 ad='int((nf+1)/2) * W/nf * 0.18u' as='int((nf+2)/2) * W/nf * 0.18u' pd='2*int((nf+1)/2) * (W/nf + 0.18u)' ps='2*int((nf+2)/2) * (W/nf + 0.18u)' nrd='0.18u / W' nrs='0.18u / W' sa=0 sb=0 sd=0
VO_m196 m196o Vmem 0
XR_m197 m197r m197r Vdd Vdd pfet_03v3 L=1.714u W=0.42u nf=1 ad='int((nf+1)/2) * W/nf * 0.18u' as='int((nf+2)/2) * W/nf * 0.18u' pd='2*int((nf+1)/2) * (W/nf + 0.18u)' ps='2*int((nf+2)/2) * (W/nf + 0.18u)' nrd='0.18u / W' nrs='0.18u / W' sa=0 sb=0 sd=0
VR_m197 nref m197r 0
XO_m197 m197o m197r Vdd Vdd pfet_03v3 L=5.595u W=0.256u nf=1 ad='int((nf+1)/2) * W/nf * 0.18u' as='int((nf+2)/2) * W/nf * 0.18u' pd='2*int((nf+1)/2) * (W/nf + 0.18u)' ps='2*int((nf+2)/2) * (W/nf + 0.18u)' nrd='0.18u / W' nrs='0.18u / W' sa=0 sb=0 sd=0
VO_m197 m197o Vmem 0
XR_m198 m198r m198r Vdd Vdd pfet_03v3 L=1.629u W=0.293u nf=1 ad='int((nf+1)/2) * W/nf * 0.18u' as='int((nf+2)/2) * W/nf * 0.18u' pd='2*int((nf+1)/2) * (W/nf + 0.18u)' ps='2*int((nf+2)/2) * (W/nf + 0.18u)' nrd='0.18u / W' nrs='0.18u / W' sa=0 sb=0 sd=0
VR_m198 nref m198r 0
XO_m198 m198o m198r Vdd Vdd pfet_03v3 L=0.325u W=1.565u nf=1 ad='int((nf+1)/2) * W/nf * 0.18u' as='int((nf+2)/2) * W/nf * 0.18u' pd='2*int((nf+1)/2) * (W/nf + 0.18u)' ps='2*int((nf+2)/2) * (W/nf + 0.18u)' nrd='0.18u / W' nrs='0.18u / W' sa=0 sb=0 sd=0
VO_m198 m198o Vmem 0
XR_m199 m199r m199r Vdd Vdd pfet_03v3 L=0.629u W=1.161u nf=1 ad='int((nf+1)/2) * W/nf * 0.18u' as='int((nf+2)/2) * W/nf * 0.18u' pd='2*int((nf+1)/2) * (W/nf + 0.18u)' ps='2*int((nf+2)/2) * (W/nf + 0.18u)' nrd='0.18u / W' nrs='0.18u / W' sa=0 sb=0 sd=0
VR_m199 nref m199r 0
XO_m199 m199o m199r Vdd Vdd pfet_03v3 L=0.465u W=1.439u nf=1 ad='int((nf+1)/2) * W/nf * 0.18u' as='int((nf+2)/2) * W/nf * 0.18u' pd='2*int((nf+1)/2) * (W/nf + 0.18u)' ps='2*int((nf+2)/2) * (W/nf + 0.18u)' nrd='0.18u / W' nrs='0.18u / W' sa=0 sb=0 sd=0
VO_m199 m199o Vmem 0
XR_m200 m200r m200r Vdd Vdd pfet_03v3 L=0.934u W=0.256u nf=1 ad='int((nf+1)/2) * W/nf * 0.18u' as='int((nf+2)/2) * W/nf * 0.18u' pd='2*int((nf+1)/2) * (W/nf + 0.18u)' ps='2*int((nf+2)/2) * (W/nf + 0.18u)' nrd='0.18u / W' nrs='0.18u / W' sa=0 sb=0 sd=0
VR_m200 nref m200r 0
XO_m200 m200o m200r Vdd Vdd pfet_03v3 L=0.789u W=0.556u nf=1 ad='int((nf+1)/2) * W/nf * 0.18u' as='int((nf+2)/2) * W/nf * 0.18u' pd='2*int((nf+1)/2) * (W/nf + 0.18u)' ps='2*int((nf+2)/2) * (W/nf + 0.18u)' nrd='0.18u / W' nrs='0.18u / W' sa=0 sb=0 sd=0
VO_m200 m200o Vmem 0
XR_m201 m201r m201r Vdd Vdd pfet_03v3 L=1.857u W=1.201u nf=1 ad='int((nf+1)/2) * W/nf * 0.18u' as='int((nf+2)/2) * W/nf * 0.18u' pd='2*int((nf+1)/2) * (W/nf + 0.18u)' ps='2*int((nf+2)/2) * (W/nf + 0.18u)' nrd='0.18u / W' nrs='0.18u / W' sa=0 sb=0 sd=0
VR_m201 nref m201r 0
XO_m201 m201o m201r Vdd Vdd pfet_03v3 L=2.239u W=0.324u nf=1 ad='int((nf+1)/2) * W/nf * 0.18u' as='int((nf+2)/2) * W/nf * 0.18u' pd='2*int((nf+1)/2) * (W/nf + 0.18u)' ps='2*int((nf+2)/2) * (W/nf + 0.18u)' nrd='0.18u / W' nrs='0.18u / W' sa=0 sb=0 sd=0
VO_m201 m201o Vmem 0
XR_m202 m202r m202r Vdd Vdd pfet_03v3 L=2.32u W=3.702u nf=1 ad='int((nf+1)/2) * W/nf * 0.18u' as='int((nf+2)/2) * W/nf * 0.18u' pd='2*int((nf+1)/2) * (W/nf + 0.18u)' ps='2*int((nf+2)/2) * (W/nf + 0.18u)' nrd='0.18u / W' nrs='0.18u / W' sa=0 sb=0 sd=0
VR_m202 nref m202r 0
XO_m202 m202o m202r Vdd Vdd pfet_03v3 L=2.148u W=1.026u nf=1 ad='int((nf+1)/2) * W/nf * 0.18u' as='int((nf+2)/2) * W/nf * 0.18u' pd='2*int((nf+1)/2) * (W/nf + 0.18u)' ps='2*int((nf+2)/2) * (W/nf + 0.18u)' nrd='0.18u / W' nrs='0.18u / W' sa=0 sb=0 sd=0
VO_m202 m202o Vmem 0
XR_m203 m203r m203r Vdd Vdd pfet_03v3 L=0.64u W=2.314u nf=1 ad='int((nf+1)/2) * W/nf * 0.18u' as='int((nf+2)/2) * W/nf * 0.18u' pd='2*int((nf+1)/2) * (W/nf + 0.18u)' ps='2*int((nf+2)/2) * (W/nf + 0.18u)' nrd='0.18u / W' nrs='0.18u / W' sa=0 sb=0 sd=0
VR_m203 nref m203r 0
XO_m203 m203o m203r Vdd Vdd pfet_03v3 L=7.277u W=1.294u nf=1 ad='int((nf+1)/2) * W/nf * 0.18u' as='int((nf+2)/2) * W/nf * 0.18u' pd='2*int((nf+1)/2) * (W/nf + 0.18u)' ps='2*int((nf+2)/2) * (W/nf + 0.18u)' nrd='0.18u / W' nrs='0.18u / W' sa=0 sb=0 sd=0
VO_m203 m203o Vmem 0
XR_m204 m204r m204r Vdd Vdd pfet_03v3 L=0.295u W=0.246u nf=1 ad='int((nf+1)/2) * W/nf * 0.18u' as='int((nf+2)/2) * W/nf * 0.18u' pd='2*int((nf+1)/2) * (W/nf + 0.18u)' ps='2*int((nf+2)/2) * (W/nf + 0.18u)' nrd='0.18u / W' nrs='0.18u / W' sa=0 sb=0 sd=0
VR_m204 nref m204r 0
XO_m204 m204o m204r Vdd Vdd pfet_03v3 L=4.099u W=1.214u nf=1 ad='int((nf+1)/2) * W/nf * 0.18u' as='int((nf+2)/2) * W/nf * 0.18u' pd='2*int((nf+1)/2) * (W/nf + 0.18u)' ps='2*int((nf+2)/2) * (W/nf + 0.18u)' nrd='0.18u / W' nrs='0.18u / W' sa=0 sb=0 sd=0
VO_m204 m204o Vmem 0
XR_m205 m205r m205r Vdd Vdd pfet_03v3 L=2.689u W=1.06u nf=1 ad='int((nf+1)/2) * W/nf * 0.18u' as='int((nf+2)/2) * W/nf * 0.18u' pd='2*int((nf+1)/2) * (W/nf + 0.18u)' ps='2*int((nf+2)/2) * (W/nf + 0.18u)' nrd='0.18u / W' nrs='0.18u / W' sa=0 sb=0 sd=0
VR_m205 nref m205r 0
XO_m205 m205o m205r Vdd Vdd pfet_03v3 L=0.549u W=1.989u nf=1 ad='int((nf+1)/2) * W/nf * 0.18u' as='int((nf+2)/2) * W/nf * 0.18u' pd='2*int((nf+1)/2) * (W/nf + 0.18u)' ps='2*int((nf+2)/2) * (W/nf + 0.18u)' nrd='0.18u / W' nrs='0.18u / W' sa=0 sb=0 sd=0
VO_m205 m205o Vmem 0
XR_m206 m206r m206r Vdd Vdd pfet_03v3 L=0.302u W=0.511u nf=1 ad='int((nf+1)/2) * W/nf * 0.18u' as='int((nf+2)/2) * W/nf * 0.18u' pd='2*int((nf+1)/2) * (W/nf + 0.18u)' ps='2*int((nf+2)/2) * (W/nf + 0.18u)' nrd='0.18u / W' nrs='0.18u / W' sa=0 sb=0 sd=0
VR_m206 nref m206r 0
XO_m206 m206o m206r Vdd Vdd pfet_03v3 L=0.396u W=0.749u nf=1 ad='int((nf+1)/2) * W/nf * 0.18u' as='int((nf+2)/2) * W/nf * 0.18u' pd='2*int((nf+1)/2) * (W/nf + 0.18u)' ps='2*int((nf+2)/2) * (W/nf + 0.18u)' nrd='0.18u / W' nrs='0.18u / W' sa=0 sb=0 sd=0
VO_m206 m206o Vmem 0
XR_m207 m207r m207r Vdd Vdd pfet_03v3 L=3.936u W=0.531u nf=1 ad='int((nf+1)/2) * W/nf * 0.18u' as='int((nf+2)/2) * W/nf * 0.18u' pd='2*int((nf+1)/2) * (W/nf + 0.18u)' ps='2*int((nf+2)/2) * (W/nf + 0.18u)' nrd='0.18u / W' nrs='0.18u / W' sa=0 sb=0 sd=0
VR_m207 nref m207r 0
XO_m207 m207o m207r Vdd Vdd pfet_03v3 L=0.619u W=1.842u nf=1 ad='int((nf+1)/2) * W/nf * 0.18u' as='int((nf+2)/2) * W/nf * 0.18u' pd='2*int((nf+1)/2) * (W/nf + 0.18u)' ps='2*int((nf+2)/2) * (W/nf + 0.18u)' nrd='0.18u / W' nrs='0.18u / W' sa=0 sb=0 sd=0
VO_m207 m207o Vmem 0
XR_m208 m208r m208r Vdd Vdd pfet_03v3 L=0.341u W=0.686u nf=1 ad='int((nf+1)/2) * W/nf * 0.18u' as='int((nf+2)/2) * W/nf * 0.18u' pd='2*int((nf+1)/2) * (W/nf + 0.18u)' ps='2*int((nf+2)/2) * (W/nf + 0.18u)' nrd='0.18u / W' nrs='0.18u / W' sa=0 sb=0 sd=0
VR_m208 nref m208r 0
XO_m208 m208o m208r Vdd Vdd pfet_03v3 L=1.329u W=0.242u nf=1 ad='int((nf+1)/2) * W/nf * 0.18u' as='int((nf+2)/2) * W/nf * 0.18u' pd='2*int((nf+1)/2) * (W/nf + 0.18u)' ps='2*int((nf+2)/2) * (W/nf + 0.18u)' nrd='0.18u / W' nrs='0.18u / W' sa=0 sb=0 sd=0
VO_m208 m208o Vmem 0
XR_m209 m209r m209r Vdd Vdd pfet_03v3 L=1.245u W=1.215u nf=1 ad='int((nf+1)/2) * W/nf * 0.18u' as='int((nf+2)/2) * W/nf * 0.18u' pd='2*int((nf+1)/2) * (W/nf + 0.18u)' ps='2*int((nf+2)/2) * (W/nf + 0.18u)' nrd='0.18u / W' nrs='0.18u / W' sa=0 sb=0 sd=0
VR_m209 nref m209r 0
XO_m209 m209o m209r Vdd Vdd pfet_03v3 L=5.104u W=0.623u nf=1 ad='int((nf+1)/2) * W/nf * 0.18u' as='int((nf+2)/2) * W/nf * 0.18u' pd='2*int((nf+1)/2) * (W/nf + 0.18u)' ps='2*int((nf+2)/2) * (W/nf + 0.18u)' nrd='0.18u / W' nrs='0.18u / W' sa=0 sb=0 sd=0
VO_m209 m209o Vmem 0
XR_m210 m210r m210r Vdd Vdd pfet_03v3 L=3.966u W=2.026u nf=1 ad='int((nf+1)/2) * W/nf * 0.18u' as='int((nf+2)/2) * W/nf * 0.18u' pd='2*int((nf+1)/2) * (W/nf + 0.18u)' ps='2*int((nf+2)/2) * (W/nf + 0.18u)' nrd='0.18u / W' nrs='0.18u / W' sa=0 sb=0 sd=0
VR_m210 nref m210r 0
XO_m210 m210o m210r Vdd Vdd pfet_03v3 L=0.432u W=1.899u nf=1 ad='int((nf+1)/2) * W/nf * 0.18u' as='int((nf+2)/2) * W/nf * 0.18u' pd='2*int((nf+1)/2) * (W/nf + 0.18u)' ps='2*int((nf+2)/2) * (W/nf + 0.18u)' nrd='0.18u / W' nrs='0.18u / W' sa=0 sb=0 sd=0
VO_m210 m210o Vmem 0
XR_m211 m211r m211r Vdd Vdd pfet_03v3 L=0.335u W=0.265u nf=1 ad='int((nf+1)/2) * W/nf * 0.18u' as='int((nf+2)/2) * W/nf * 0.18u' pd='2*int((nf+1)/2) * (W/nf + 0.18u)' ps='2*int((nf+2)/2) * (W/nf + 0.18u)' nrd='0.18u / W' nrs='0.18u / W' sa=0 sb=0 sd=0
VR_m211 nref m211r 0
XO_m211 m211o m211r Vdd Vdd pfet_03v3 L=3.431u W=1.133u nf=1 ad='int((nf+1)/2) * W/nf * 0.18u' as='int((nf+2)/2) * W/nf * 0.18u' pd='2*int((nf+1)/2) * (W/nf + 0.18u)' ps='2*int((nf+2)/2) * (W/nf + 0.18u)' nrd='0.18u / W' nrs='0.18u / W' sa=0 sb=0 sd=0
VO_m211 m211o Vmem 0
XR_m212 m212r m212r Vdd Vdd pfet_03v3 L=0.549u W=0.814u nf=1 ad='int((nf+1)/2) * W/nf * 0.18u' as='int((nf+2)/2) * W/nf * 0.18u' pd='2*int((nf+1)/2) * (W/nf + 0.18u)' ps='2*int((nf+2)/2) * (W/nf + 0.18u)' nrd='0.18u / W' nrs='0.18u / W' sa=0 sb=0 sd=0
VR_m212 nref m212r 0
XO_m212 m212o m212r Vdd Vdd pfet_03v3 L=0.342u W=0.472u nf=1 ad='int((nf+1)/2) * W/nf * 0.18u' as='int((nf+2)/2) * W/nf * 0.18u' pd='2*int((nf+1)/2) * (W/nf + 0.18u)' ps='2*int((nf+2)/2) * (W/nf + 0.18u)' nrd='0.18u / W' nrs='0.18u / W' sa=0 sb=0 sd=0
VO_m212 m212o Vmem 0
XR_m213 m213r m213r Vdd Vdd pfet_03v3 L=1.767u W=1.186u nf=1 ad='int((nf+1)/2) * W/nf * 0.18u' as='int((nf+2)/2) * W/nf * 0.18u' pd='2*int((nf+1)/2) * (W/nf + 0.18u)' ps='2*int((nf+2)/2) * (W/nf + 0.18u)' nrd='0.18u / W' nrs='0.18u / W' sa=0 sb=0 sd=0
VR_m213 nref m213r 0
XO_m213 m213o m213r Vdd Vdd pfet_03v3 L=0.884u W=2.407u nf=1 ad='int((nf+1)/2) * W/nf * 0.18u' as='int((nf+2)/2) * W/nf * 0.18u' pd='2*int((nf+1)/2) * (W/nf + 0.18u)' ps='2*int((nf+2)/2) * (W/nf + 0.18u)' nrd='0.18u / W' nrs='0.18u / W' sa=0 sb=0 sd=0
VO_m213 m213o Vmem 0
XR_m214 m214r m214r Vdd Vdd pfet_03v3 L=0.438u W=1.767u nf=1 ad='int((nf+1)/2) * W/nf * 0.18u' as='int((nf+2)/2) * W/nf * 0.18u' pd='2*int((nf+1)/2) * (W/nf + 0.18u)' ps='2*int((nf+2)/2) * (W/nf + 0.18u)' nrd='0.18u / W' nrs='0.18u / W' sa=0 sb=0 sd=0
VR_m214 nref m214r 0
XO_m214 m214o m214r Vdd Vdd pfet_03v3 L=0.99u W=1.982u nf=1 ad='int((nf+1)/2) * W/nf * 0.18u' as='int((nf+2)/2) * W/nf * 0.18u' pd='2*int((nf+1)/2) * (W/nf + 0.18u)' ps='2*int((nf+2)/2) * (W/nf + 0.18u)' nrd='0.18u / W' nrs='0.18u / W' sa=0 sb=0 sd=0
VO_m214 m214o Vmem 0
XR_m215 m215r m215r Vdd Vdd pfet_03v3 L=1.062u W=1.885u nf=1 ad='int((nf+1)/2) * W/nf * 0.18u' as='int((nf+2)/2) * W/nf * 0.18u' pd='2*int((nf+1)/2) * (W/nf + 0.18u)' ps='2*int((nf+2)/2) * (W/nf + 0.18u)' nrd='0.18u / W' nrs='0.18u / W' sa=0 sb=0 sd=0
VR_m215 nref m215r 0
XO_m215 m215o m215r Vdd Vdd pfet_03v3 L=2.004u W=2.134u nf=1 ad='int((nf+1)/2) * W/nf * 0.18u' as='int((nf+2)/2) * W/nf * 0.18u' pd='2*int((nf+1)/2) * (W/nf + 0.18u)' ps='2*int((nf+2)/2) * (W/nf + 0.18u)' nrd='0.18u / W' nrs='0.18u / W' sa=0 sb=0 sd=0
VO_m215 m215o Vmem 0
XR_m216 m216r m216r Vdd Vdd pfet_03v3 L=1.629u W=0.272u nf=1 ad='int((nf+1)/2) * W/nf * 0.18u' as='int((nf+2)/2) * W/nf * 0.18u' pd='2*int((nf+1)/2) * (W/nf + 0.18u)' ps='2*int((nf+2)/2) * (W/nf + 0.18u)' nrd='0.18u / W' nrs='0.18u / W' sa=0 sb=0 sd=0
VR_m216 nref m216r 0
XO_m216 m216o m216r Vdd Vdd pfet_03v3 L=2.221u W=0.707u nf=1 ad='int((nf+1)/2) * W/nf * 0.18u' as='int((nf+2)/2) * W/nf * 0.18u' pd='2*int((nf+1)/2) * (W/nf + 0.18u)' ps='2*int((nf+2)/2) * (W/nf + 0.18u)' nrd='0.18u / W' nrs='0.18u / W' sa=0 sb=0 sd=0
VO_m216 m216o Vmem 0
XR_m217 m217r m217r Vdd Vdd pfet_03v3 L=3.113u W=1.195u nf=1 ad='int((nf+1)/2) * W/nf * 0.18u' as='int((nf+2)/2) * W/nf * 0.18u' pd='2*int((nf+1)/2) * (W/nf + 0.18u)' ps='2*int((nf+2)/2) * (W/nf + 0.18u)' nrd='0.18u / W' nrs='0.18u / W' sa=0 sb=0 sd=0
VR_m217 nref m217r 0
XO_m217 m217o m217r Vdd Vdd pfet_03v3 L=5.229u W=1.964u nf=1 ad='int((nf+1)/2) * W/nf * 0.18u' as='int((nf+2)/2) * W/nf * 0.18u' pd='2*int((nf+1)/2) * (W/nf + 0.18u)' ps='2*int((nf+2)/2) * (W/nf + 0.18u)' nrd='0.18u / W' nrs='0.18u / W' sa=0 sb=0 sd=0
VO_m217 m217o Vmem 0
XR_m218 m218r m218r Vdd Vdd pfet_03v3 L=3.186u W=1.912u nf=1 ad='int((nf+1)/2) * W/nf * 0.18u' as='int((nf+2)/2) * W/nf * 0.18u' pd='2*int((nf+1)/2) * (W/nf + 0.18u)' ps='2*int((nf+2)/2) * (W/nf + 0.18u)' nrd='0.18u / W' nrs='0.18u / W' sa=0 sb=0 sd=0
VR_m218 nref m218r 0
XO_m218 m218o m218r Vdd Vdd pfet_03v3 L=2.569u W=2.164u nf=1 ad='int((nf+1)/2) * W/nf * 0.18u' as='int((nf+2)/2) * W/nf * 0.18u' pd='2*int((nf+1)/2) * (W/nf + 0.18u)' ps='2*int((nf+2)/2) * (W/nf + 0.18u)' nrd='0.18u / W' nrs='0.18u / W' sa=0 sb=0 sd=0
VO_m218 m218o Vmem 0
XR_m219 m219r m219r Vdd Vdd pfet_03v3 L=2.481u W=0.946u nf=1 ad='int((nf+1)/2) * W/nf * 0.18u' as='int((nf+2)/2) * W/nf * 0.18u' pd='2*int((nf+1)/2) * (W/nf + 0.18u)' ps='2*int((nf+2)/2) * (W/nf + 0.18u)' nrd='0.18u / W' nrs='0.18u / W' sa=0 sb=0 sd=0
VR_m219 nref m219r 0
XO_m219 m219o m219r Vdd Vdd pfet_03v3 L=1.898u W=0.819u nf=1 ad='int((nf+1)/2) * W/nf * 0.18u' as='int((nf+2)/2) * W/nf * 0.18u' pd='2*int((nf+1)/2) * (W/nf + 0.18u)' ps='2*int((nf+2)/2) * (W/nf + 0.18u)' nrd='0.18u / W' nrs='0.18u / W' sa=0 sb=0 sd=0
VO_m219 m219o Vmem 0
XR_m220 m220r m220r Vdd Vdd pfet_03v3 L=0.342u W=1.905u nf=1 ad='int((nf+1)/2) * W/nf * 0.18u' as='int((nf+2)/2) * W/nf * 0.18u' pd='2*int((nf+1)/2) * (W/nf + 0.18u)' ps='2*int((nf+2)/2) * (W/nf + 0.18u)' nrd='0.18u / W' nrs='0.18u / W' sa=0 sb=0 sd=0
VR_m220 nref m220r 0
XO_m220 m220o m220r Vdd Vdd pfet_03v3 L=0.571u W=0.965u nf=1 ad='int((nf+1)/2) * W/nf * 0.18u' as='int((nf+2)/2) * W/nf * 0.18u' pd='2*int((nf+1)/2) * (W/nf + 0.18u)' ps='2*int((nf+2)/2) * (W/nf + 0.18u)' nrd='0.18u / W' nrs='0.18u / W' sa=0 sb=0 sd=0
VO_m220 m220o Vmem 0
XR_m221 m221r m221r Vdd Vdd pfet_03v3 L=1.35u W=1.211u nf=1 ad='int((nf+1)/2) * W/nf * 0.18u' as='int((nf+2)/2) * W/nf * 0.18u' pd='2*int((nf+1)/2) * (W/nf + 0.18u)' ps='2*int((nf+2)/2) * (W/nf + 0.18u)' nrd='0.18u / W' nrs='0.18u / W' sa=0 sb=0 sd=0
VR_m221 nref m221r 0
XO_m221 m221o m221r Vdd Vdd pfet_03v3 L=2.088u W=1.262u nf=1 ad='int((nf+1)/2) * W/nf * 0.18u' as='int((nf+2)/2) * W/nf * 0.18u' pd='2*int((nf+1)/2) * (W/nf + 0.18u)' ps='2*int((nf+2)/2) * (W/nf + 0.18u)' nrd='0.18u / W' nrs='0.18u / W' sa=0 sb=0 sd=0
VO_m221 m221o Vmem 0
XR_m222 m222r m222r Vdd Vdd pfet_03v3 L=0.855u W=2.684u nf=1 ad='int((nf+1)/2) * W/nf * 0.18u' as='int((nf+2)/2) * W/nf * 0.18u' pd='2*int((nf+1)/2) * (W/nf + 0.18u)' ps='2*int((nf+2)/2) * (W/nf + 0.18u)' nrd='0.18u / W' nrs='0.18u / W' sa=0 sb=0 sd=0
VR_m222 nref m222r 0
XO_m222 m222o m222r Vdd Vdd pfet_03v3 L=6.681u W=1.212u nf=1 ad='int((nf+1)/2) * W/nf * 0.18u' as='int((nf+2)/2) * W/nf * 0.18u' pd='2*int((nf+1)/2) * (W/nf + 0.18u)' ps='2*int((nf+2)/2) * (W/nf + 0.18u)' nrd='0.18u / W' nrs='0.18u / W' sa=0 sb=0 sd=0
VO_m222 m222o Vmem 0
XR_m223 m223r m223r Vdd Vdd pfet_03v3 L=1.549u W=2.156u nf=1 ad='int((nf+1)/2) * W/nf * 0.18u' as='int((nf+2)/2) * W/nf * 0.18u' pd='2*int((nf+1)/2) * (W/nf + 0.18u)' ps='2*int((nf+2)/2) * (W/nf + 0.18u)' nrd='0.18u / W' nrs='0.18u / W' sa=0 sb=0 sd=0
VR_m223 nref m223r 0
XO_m223 m223o m223r Vdd Vdd pfet_03v3 L=6.162u W=1.247u nf=1 ad='int((nf+1)/2) * W/nf * 0.18u' as='int((nf+2)/2) * W/nf * 0.18u' pd='2*int((nf+1)/2) * (W/nf + 0.18u)' ps='2*int((nf+2)/2) * (W/nf + 0.18u)' nrd='0.18u / W' nrs='0.18u / W' sa=0 sb=0 sd=0
VO_m223 m223o Vmem 0
XR_m224 m224r m224r Vdd Vdd pfet_03v3 L=0.892u W=0.51u nf=1 ad='int((nf+1)/2) * W/nf * 0.18u' as='int((nf+2)/2) * W/nf * 0.18u' pd='2*int((nf+1)/2) * (W/nf + 0.18u)' ps='2*int((nf+2)/2) * (W/nf + 0.18u)' nrd='0.18u / W' nrs='0.18u / W' sa=0 sb=0 sd=0
VR_m224 nref m224r 0
XO_m224 m224o m224r Vdd Vdd pfet_03v3 L=0.848u W=1.575u nf=1 ad='int((nf+1)/2) * W/nf * 0.18u' as='int((nf+2)/2) * W/nf * 0.18u' pd='2*int((nf+1)/2) * (W/nf + 0.18u)' ps='2*int((nf+2)/2) * (W/nf + 0.18u)' nrd='0.18u / W' nrs='0.18u / W' sa=0 sb=0 sd=0
VO_m224 m224o Vmem 0
XR_m225 m225r m225r Vdd Vdd pfet_03v3 L=0.916u W=0.735u nf=1 ad='int((nf+1)/2) * W/nf * 0.18u' as='int((nf+2)/2) * W/nf * 0.18u' pd='2*int((nf+1)/2) * (W/nf + 0.18u)' ps='2*int((nf+2)/2) * (W/nf + 0.18u)' nrd='0.18u / W' nrs='0.18u / W' sa=0 sb=0 sd=0
VR_m225 nref m225r 0
XO_m225 m225o m225r Vdd Vdd pfet_03v3 L=3.263u W=0.332u nf=1 ad='int((nf+1)/2) * W/nf * 0.18u' as='int((nf+2)/2) * W/nf * 0.18u' pd='2*int((nf+1)/2) * (W/nf + 0.18u)' ps='2*int((nf+2)/2) * (W/nf + 0.18u)' nrd='0.18u / W' nrs='0.18u / W' sa=0 sb=0 sd=0
VO_m225 m225o Vmem 0
XR_m226 m226r m226r Vdd Vdd pfet_03v3 L=1.79u W=0.244u nf=1 ad='int((nf+1)/2) * W/nf * 0.18u' as='int((nf+2)/2) * W/nf * 0.18u' pd='2*int((nf+1)/2) * (W/nf + 0.18u)' ps='2*int((nf+2)/2) * (W/nf + 0.18u)' nrd='0.18u / W' nrs='0.18u / W' sa=0 sb=0 sd=0
VR_m226 nref m226r 0
XO_m226 m226o m226r Vdd Vdd pfet_03v3 L=2.541u W=1.13u nf=1 ad='int((nf+1)/2) * W/nf * 0.18u' as='int((nf+2)/2) * W/nf * 0.18u' pd='2*int((nf+1)/2) * (W/nf + 0.18u)' ps='2*int((nf+2)/2) * (W/nf + 0.18u)' nrd='0.18u / W' nrs='0.18u / W' sa=0 sb=0 sd=0
VO_m226 m226o Vmem 0
XR_m227 m227r m227r Vdd Vdd pfet_03v3 L=0.998u W=3.864u nf=1 ad='int((nf+1)/2) * W/nf * 0.18u' as='int((nf+2)/2) * W/nf * 0.18u' pd='2*int((nf+1)/2) * (W/nf + 0.18u)' ps='2*int((nf+2)/2) * (W/nf + 0.18u)' nrd='0.18u / W' nrs='0.18u / W' sa=0 sb=0 sd=0
VR_m227 nref m227r 0
XO_m227 m227o m227r Vdd Vdd pfet_03v3 L=0.9u W=0.231u nf=1 ad='int((nf+1)/2) * W/nf * 0.18u' as='int((nf+2)/2) * W/nf * 0.18u' pd='2*int((nf+1)/2) * (W/nf + 0.18u)' ps='2*int((nf+2)/2) * (W/nf + 0.18u)' nrd='0.18u / W' nrs='0.18u / W' sa=0 sb=0 sd=0
VO_m227 m227o Vmem 0
XR_m228 m228r m228r Vdd Vdd pfet_03v3 L=0.879u W=0.744u nf=1 ad='int((nf+1)/2) * W/nf * 0.18u' as='int((nf+2)/2) * W/nf * 0.18u' pd='2*int((nf+1)/2) * (W/nf + 0.18u)' ps='2*int((nf+2)/2) * (W/nf + 0.18u)' nrd='0.18u / W' nrs='0.18u / W' sa=0 sb=0 sd=0
VR_m228 nref m228r 0
XO_m228 m228o m228r Vdd Vdd pfet_03v3 L=0.348u W=1.047u nf=1 ad='int((nf+1)/2) * W/nf * 0.18u' as='int((nf+2)/2) * W/nf * 0.18u' pd='2*int((nf+1)/2) * (W/nf + 0.18u)' ps='2*int((nf+2)/2) * (W/nf + 0.18u)' nrd='0.18u / W' nrs='0.18u / W' sa=0 sb=0 sd=0
VO_m228 m228o Vmem 0
XR_m229 m229r m229r Vdd Vdd pfet_03v3 L=0.775u W=0.991u nf=1 ad='int((nf+1)/2) * W/nf * 0.18u' as='int((nf+2)/2) * W/nf * 0.18u' pd='2*int((nf+1)/2) * (W/nf + 0.18u)' ps='2*int((nf+2)/2) * (W/nf + 0.18u)' nrd='0.18u / W' nrs='0.18u / W' sa=0 sb=0 sd=0
VR_m229 nref m229r 0
XO_m229 m229o m229r Vdd Vdd pfet_03v3 L=2.425u W=0.392u nf=1 ad='int((nf+1)/2) * W/nf * 0.18u' as='int((nf+2)/2) * W/nf * 0.18u' pd='2*int((nf+1)/2) * (W/nf + 0.18u)' ps='2*int((nf+2)/2) * (W/nf + 0.18u)' nrd='0.18u / W' nrs='0.18u / W' sa=0 sb=0 sd=0
VO_m229 m229o Vmem 0
XR_m230 m230r m230r Vdd Vdd pfet_03v3 L=3.181u W=1.496u nf=1 ad='int((nf+1)/2) * W/nf * 0.18u' as='int((nf+2)/2) * W/nf * 0.18u' pd='2*int((nf+1)/2) * (W/nf + 0.18u)' ps='2*int((nf+2)/2) * (W/nf + 0.18u)' nrd='0.18u / W' nrs='0.18u / W' sa=0 sb=0 sd=0
VR_m230 nref m230r 0
XO_m230 m230o m230r Vdd Vdd pfet_03v3 L=0.709u W=0.918u nf=1 ad='int((nf+1)/2) * W/nf * 0.18u' as='int((nf+2)/2) * W/nf * 0.18u' pd='2*int((nf+1)/2) * (W/nf + 0.18u)' ps='2*int((nf+2)/2) * (W/nf + 0.18u)' nrd='0.18u / W' nrs='0.18u / W' sa=0 sb=0 sd=0
VO_m230 m230o Vmem 0
XR_m231 m231r m231r Vdd Vdd pfet_03v3 L=0.767u W=0.568u nf=1 ad='int((nf+1)/2) * W/nf * 0.18u' as='int((nf+2)/2) * W/nf * 0.18u' pd='2*int((nf+1)/2) * (W/nf + 0.18u)' ps='2*int((nf+2)/2) * (W/nf + 0.18u)' nrd='0.18u / W' nrs='0.18u / W' sa=0 sb=0 sd=0
VR_m231 nref m231r 0
XO_m231 m231o m231r Vdd Vdd pfet_03v3 L=2.478u W=2.956u nf=1 ad='int((nf+1)/2) * W/nf * 0.18u' as='int((nf+2)/2) * W/nf * 0.18u' pd='2*int((nf+1)/2) * (W/nf + 0.18u)' ps='2*int((nf+2)/2) * (W/nf + 0.18u)' nrd='0.18u / W' nrs='0.18u / W' sa=0 sb=0 sd=0
VO_m231 m231o Vmem 0
XR_m232 m232r m232r Vdd Vdd pfet_03v3 L=0.607u W=0.642u nf=1 ad='int((nf+1)/2) * W/nf * 0.18u' as='int((nf+2)/2) * W/nf * 0.18u' pd='2*int((nf+1)/2) * (W/nf + 0.18u)' ps='2*int((nf+2)/2) * (W/nf + 0.18u)' nrd='0.18u / W' nrs='0.18u / W' sa=0 sb=0 sd=0
VR_m232 nref m232r 0
XO_m232 m232o m232r Vdd Vdd pfet_03v3 L=0.726u W=0.371u nf=1 ad='int((nf+1)/2) * W/nf * 0.18u' as='int((nf+2)/2) * W/nf * 0.18u' pd='2*int((nf+1)/2) * (W/nf + 0.18u)' ps='2*int((nf+2)/2) * (W/nf + 0.18u)' nrd='0.18u / W' nrs='0.18u / W' sa=0 sb=0 sd=0
VO_m232 m232o Vmem 0
XR_m233 m233r m233r Vdd Vdd pfet_03v3 L=0.287u W=1.093u nf=1 ad='int((nf+1)/2) * W/nf * 0.18u' as='int((nf+2)/2) * W/nf * 0.18u' pd='2*int((nf+1)/2) * (W/nf + 0.18u)' ps='2*int((nf+2)/2) * (W/nf + 0.18u)' nrd='0.18u / W' nrs='0.18u / W' sa=0 sb=0 sd=0
VR_m233 nref m233r 0
XO_m233 m233o m233r Vdd Vdd pfet_03v3 L=0.901u W=0.588u nf=1 ad='int((nf+1)/2) * W/nf * 0.18u' as='int((nf+2)/2) * W/nf * 0.18u' pd='2*int((nf+1)/2) * (W/nf + 0.18u)' ps='2*int((nf+2)/2) * (W/nf + 0.18u)' nrd='0.18u / W' nrs='0.18u / W' sa=0 sb=0 sd=0
VO_m233 m233o Vmem 0
XR_m234 m234r m234r Vdd Vdd pfet_03v3 L=0.561u W=3.798u nf=1 ad='int((nf+1)/2) * W/nf * 0.18u' as='int((nf+2)/2) * W/nf * 0.18u' pd='2*int((nf+1)/2) * (W/nf + 0.18u)' ps='2*int((nf+2)/2) * (W/nf + 0.18u)' nrd='0.18u / W' nrs='0.18u / W' sa=0 sb=0 sd=0
VR_m234 nref m234r 0
XO_m234 m234o m234r Vdd Vdd pfet_03v3 L=3.866u W=1.282u nf=1 ad='int((nf+1)/2) * W/nf * 0.18u' as='int((nf+2)/2) * W/nf * 0.18u' pd='2*int((nf+1)/2) * (W/nf + 0.18u)' ps='2*int((nf+2)/2) * (W/nf + 0.18u)' nrd='0.18u / W' nrs='0.18u / W' sa=0 sb=0 sd=0
VO_m234 m234o Vmem 0
XR_m235 m235r m235r Vdd Vdd pfet_03v3 L=1.489u W=2.932u nf=1 ad='int((nf+1)/2) * W/nf * 0.18u' as='int((nf+2)/2) * W/nf * 0.18u' pd='2*int((nf+1)/2) * (W/nf + 0.18u)' ps='2*int((nf+2)/2) * (W/nf + 0.18u)' nrd='0.18u / W' nrs='0.18u / W' sa=0 sb=0 sd=0
VR_m235 nref m235r 0
XO_m235 m235o m235r Vdd Vdd pfet_03v3 L=4.52u W=0.556u nf=1 ad='int((nf+1)/2) * W/nf * 0.18u' as='int((nf+2)/2) * W/nf * 0.18u' pd='2*int((nf+1)/2) * (W/nf + 0.18u)' ps='2*int((nf+2)/2) * (W/nf + 0.18u)' nrd='0.18u / W' nrs='0.18u / W' sa=0 sb=0 sd=0
VO_m235 m235o Vmem 0
XR_m236 m236r m236r Vdd Vdd pfet_03v3 L=3.911u W=2.003u nf=1 ad='int((nf+1)/2) * W/nf * 0.18u' as='int((nf+2)/2) * W/nf * 0.18u' pd='2*int((nf+1)/2) * (W/nf + 0.18u)' ps='2*int((nf+2)/2) * (W/nf + 0.18u)' nrd='0.18u / W' nrs='0.18u / W' sa=0 sb=0 sd=0
VR_m236 nref m236r 0
XO_m236 m236o m236r Vdd Vdd pfet_03v3 L=4.326u W=2.733u nf=1 ad='int((nf+1)/2) * W/nf * 0.18u' as='int((nf+2)/2) * W/nf * 0.18u' pd='2*int((nf+1)/2) * (W/nf + 0.18u)' ps='2*int((nf+2)/2) * (W/nf + 0.18u)' nrd='0.18u / W' nrs='0.18u / W' sa=0 sb=0 sd=0
VO_m236 m236o Vmem 0
XR_m237 m237r m237r Vdd Vdd pfet_03v3 L=1.719u W=1.65u nf=1 ad='int((nf+1)/2) * W/nf * 0.18u' as='int((nf+2)/2) * W/nf * 0.18u' pd='2*int((nf+1)/2) * (W/nf + 0.18u)' ps='2*int((nf+2)/2) * (W/nf + 0.18u)' nrd='0.18u / W' nrs='0.18u / W' sa=0 sb=0 sd=0
VR_m237 nref m237r 0
XO_m237 m237o m237r Vdd Vdd pfet_03v3 L=1.533u W=1.599u nf=1 ad='int((nf+1)/2) * W/nf * 0.18u' as='int((nf+2)/2) * W/nf * 0.18u' pd='2*int((nf+1)/2) * (W/nf + 0.18u)' ps='2*int((nf+2)/2) * (W/nf + 0.18u)' nrd='0.18u / W' nrs='0.18u / W' sa=0 sb=0 sd=0
VO_m237 m237o Vmem 0
XR_m238 m238r m238r Vdd Vdd pfet_03v3 L=0.762u W=1.096u nf=1 ad='int((nf+1)/2) * W/nf * 0.18u' as='int((nf+2)/2) * W/nf * 0.18u' pd='2*int((nf+1)/2) * (W/nf + 0.18u)' ps='2*int((nf+2)/2) * (W/nf + 0.18u)' nrd='0.18u / W' nrs='0.18u / W' sa=0 sb=0 sd=0
VR_m238 nref m238r 0
XO_m238 m238o m238r Vdd Vdd pfet_03v3 L=2.215u W=1.009u nf=1 ad='int((nf+1)/2) * W/nf * 0.18u' as='int((nf+2)/2) * W/nf * 0.18u' pd='2*int((nf+1)/2) * (W/nf + 0.18u)' ps='2*int((nf+2)/2) * (W/nf + 0.18u)' nrd='0.18u / W' nrs='0.18u / W' sa=0 sb=0 sd=0
VO_m238 m238o Vmem 0
XR_m239 m239r m239r Vdd Vdd pfet_03v3 L=3.464u W=2.71u nf=1 ad='int((nf+1)/2) * W/nf * 0.18u' as='int((nf+2)/2) * W/nf * 0.18u' pd='2*int((nf+1)/2) * (W/nf + 0.18u)' ps='2*int((nf+2)/2) * (W/nf + 0.18u)' nrd='0.18u / W' nrs='0.18u / W' sa=0 sb=0 sd=0
VR_m239 nref m239r 0
XO_m239 m239o m239r Vdd Vdd pfet_03v3 L=4.165u W=1.077u nf=1 ad='int((nf+1)/2) * W/nf * 0.18u' as='int((nf+2)/2) * W/nf * 0.18u' pd='2*int((nf+1)/2) * (W/nf + 0.18u)' ps='2*int((nf+2)/2) * (W/nf + 0.18u)' nrd='0.18u / W' nrs='0.18u / W' sa=0 sb=0 sd=0
VO_m239 m239o Vmem 0
XR_m240 m240r m240r Vdd Vdd pfet_03v3 L=0.345u W=1.476u nf=1 ad='int((nf+1)/2) * W/nf * 0.18u' as='int((nf+2)/2) * W/nf * 0.18u' pd='2*int((nf+1)/2) * (W/nf + 0.18u)' ps='2*int((nf+2)/2) * (W/nf + 0.18u)' nrd='0.18u / W' nrs='0.18u / W' sa=0 sb=0 sd=0
VR_m240 nref m240r 0
XO_m240 m240o m240r Vdd Vdd pfet_03v3 L=1.412u W=0.267u nf=1 ad='int((nf+1)/2) * W/nf * 0.18u' as='int((nf+2)/2) * W/nf * 0.18u' pd='2*int((nf+1)/2) * (W/nf + 0.18u)' ps='2*int((nf+2)/2) * (W/nf + 0.18u)' nrd='0.18u / W' nrs='0.18u / W' sa=0 sb=0 sd=0
VO_m240 m240o Vmem 0
XR_m241 m241r m241r Vdd Vdd pfet_03v3 L=1.046u W=0.635u nf=1 ad='int((nf+1)/2) * W/nf * 0.18u' as='int((nf+2)/2) * W/nf * 0.18u' pd='2*int((nf+1)/2) * (W/nf + 0.18u)' ps='2*int((nf+2)/2) * (W/nf + 0.18u)' nrd='0.18u / W' nrs='0.18u / W' sa=0 sb=0 sd=0
VR_m241 nref m241r 0
XO_m241 m241o m241r Vdd Vdd pfet_03v3 L=1.12u W=0.464u nf=1 ad='int((nf+1)/2) * W/nf * 0.18u' as='int((nf+2)/2) * W/nf * 0.18u' pd='2*int((nf+1)/2) * (W/nf + 0.18u)' ps='2*int((nf+2)/2) * (W/nf + 0.18u)' nrd='0.18u / W' nrs='0.18u / W' sa=0 sb=0 sd=0
VO_m241 m241o Vmem 0
XR_m242 m242r m242r Vdd Vdd pfet_03v3 L=2.568u W=0.473u nf=1 ad='int((nf+1)/2) * W/nf * 0.18u' as='int((nf+2)/2) * W/nf * 0.18u' pd='2*int((nf+1)/2) * (W/nf + 0.18u)' ps='2*int((nf+2)/2) * (W/nf + 0.18u)' nrd='0.18u / W' nrs='0.18u / W' sa=0 sb=0 sd=0
VR_m242 nref m242r 0
XO_m242 m242o m242r Vdd Vdd pfet_03v3 L=5.472u W=0.243u nf=1 ad='int((nf+1)/2) * W/nf * 0.18u' as='int((nf+2)/2) * W/nf * 0.18u' pd='2*int((nf+1)/2) * (W/nf + 0.18u)' ps='2*int((nf+2)/2) * (W/nf + 0.18u)' nrd='0.18u / W' nrs='0.18u / W' sa=0 sb=0 sd=0
VO_m242 m242o Vmem 0
XR_m243 m243r m243r Vdd Vdd pfet_03v3 L=1.27u W=0.538u nf=1 ad='int((nf+1)/2) * W/nf * 0.18u' as='int((nf+2)/2) * W/nf * 0.18u' pd='2*int((nf+1)/2) * (W/nf + 0.18u)' ps='2*int((nf+2)/2) * (W/nf + 0.18u)' nrd='0.18u / W' nrs='0.18u / W' sa=0 sb=0 sd=0
VR_m243 nref m243r 0
XO_m243 m243o m243r Vdd Vdd pfet_03v3 L=2.497u W=0.591u nf=1 ad='int((nf+1)/2) * W/nf * 0.18u' as='int((nf+2)/2) * W/nf * 0.18u' pd='2*int((nf+1)/2) * (W/nf + 0.18u)' ps='2*int((nf+2)/2) * (W/nf + 0.18u)' nrd='0.18u / W' nrs='0.18u / W' sa=0 sb=0 sd=0
VO_m243 m243o Vmem 0
XR_m244 m244r m244r Vdd Vdd pfet_03v3 L=0.547u W=0.891u nf=1 ad='int((nf+1)/2) * W/nf * 0.18u' as='int((nf+2)/2) * W/nf * 0.18u' pd='2*int((nf+1)/2) * (W/nf + 0.18u)' ps='2*int((nf+2)/2) * (W/nf + 0.18u)' nrd='0.18u / W' nrs='0.18u / W' sa=0 sb=0 sd=0
VR_m244 nref m244r 0
XO_m244 m244o m244r Vdd Vdd pfet_03v3 L=0.338u W=0.942u nf=1 ad='int((nf+1)/2) * W/nf * 0.18u' as='int((nf+2)/2) * W/nf * 0.18u' pd='2*int((nf+1)/2) * (W/nf + 0.18u)' ps='2*int((nf+2)/2) * (W/nf + 0.18u)' nrd='0.18u / W' nrs='0.18u / W' sa=0 sb=0 sd=0
VO_m244 m244o Vmem 0
XR_m245 m245r m245r Vdd Vdd pfet_03v3 L=0.919u W=0.472u nf=1 ad='int((nf+1)/2) * W/nf * 0.18u' as='int((nf+2)/2) * W/nf * 0.18u' pd='2*int((nf+1)/2) * (W/nf + 0.18u)' ps='2*int((nf+2)/2) * (W/nf + 0.18u)' nrd='0.18u / W' nrs='0.18u / W' sa=0 sb=0 sd=0
VR_m245 nref m245r 0
XO_m245 m245o m245r Vdd Vdd pfet_03v3 L=6.601u W=3.485u nf=1 ad='int((nf+1)/2) * W/nf * 0.18u' as='int((nf+2)/2) * W/nf * 0.18u' pd='2*int((nf+1)/2) * (W/nf + 0.18u)' ps='2*int((nf+2)/2) * (W/nf + 0.18u)' nrd='0.18u / W' nrs='0.18u / W' sa=0 sb=0 sd=0
VO_m245 m245o Vmem 0
XR_m246 m246r m246r Vdd Vdd pfet_03v3 L=2.006u W=0.925u nf=1 ad='int((nf+1)/2) * W/nf * 0.18u' as='int((nf+2)/2) * W/nf * 0.18u' pd='2*int((nf+1)/2) * (W/nf + 0.18u)' ps='2*int((nf+2)/2) * (W/nf + 0.18u)' nrd='0.18u / W' nrs='0.18u / W' sa=0 sb=0 sd=0
VR_m246 nref m246r 0
XO_m246 m246o m246r Vdd Vdd pfet_03v3 L=2.261u W=2.35u nf=1 ad='int((nf+1)/2) * W/nf * 0.18u' as='int((nf+2)/2) * W/nf * 0.18u' pd='2*int((nf+1)/2) * (W/nf + 0.18u)' ps='2*int((nf+2)/2) * (W/nf + 0.18u)' nrd='0.18u / W' nrs='0.18u / W' sa=0 sb=0 sd=0
VO_m246 m246o Vmem 0
XR_m247 m247r m247r Vdd Vdd pfet_03v3 L=1.154u W=0.673u nf=1 ad='int((nf+1)/2) * W/nf * 0.18u' as='int((nf+2)/2) * W/nf * 0.18u' pd='2*int((nf+1)/2) * (W/nf + 0.18u)' ps='2*int((nf+2)/2) * (W/nf + 0.18u)' nrd='0.18u / W' nrs='0.18u / W' sa=0 sb=0 sd=0
VR_m247 nref m247r 0
XO_m247 m247o m247r Vdd Vdd pfet_03v3 L=0.376u W=0.83u nf=1 ad='int((nf+1)/2) * W/nf * 0.18u' as='int((nf+2)/2) * W/nf * 0.18u' pd='2*int((nf+1)/2) * (W/nf + 0.18u)' ps='2*int((nf+2)/2) * (W/nf + 0.18u)' nrd='0.18u / W' nrs='0.18u / W' sa=0 sb=0 sd=0
VO_m247 m247o Vmem 0
XR_m248 m248r m248r Vdd Vdd pfet_03v3 L=0.411u W=0.438u nf=1 ad='int((nf+1)/2) * W/nf * 0.18u' as='int((nf+2)/2) * W/nf * 0.18u' pd='2*int((nf+1)/2) * (W/nf + 0.18u)' ps='2*int((nf+2)/2) * (W/nf + 0.18u)' nrd='0.18u / W' nrs='0.18u / W' sa=0 sb=0 sd=0
VR_m248 nref m248r 0
XO_m248 m248o m248r Vdd Vdd pfet_03v3 L=5.246u W=3.588u nf=1 ad='int((nf+1)/2) * W/nf * 0.18u' as='int((nf+2)/2) * W/nf * 0.18u' pd='2*int((nf+1)/2) * (W/nf + 0.18u)' ps='2*int((nf+2)/2) * (W/nf + 0.18u)' nrd='0.18u / W' nrs='0.18u / W' sa=0 sb=0 sd=0
VO_m248 m248o Vmem 0
XR_m249 m249r m249r Vdd Vdd pfet_03v3 L=0.852u W=1.296u nf=1 ad='int((nf+1)/2) * W/nf * 0.18u' as='int((nf+2)/2) * W/nf * 0.18u' pd='2*int((nf+1)/2) * (W/nf + 0.18u)' ps='2*int((nf+2)/2) * (W/nf + 0.18u)' nrd='0.18u / W' nrs='0.18u / W' sa=0 sb=0 sd=0
VR_m249 nref m249r 0
XO_m249 m249o m249r Vdd Vdd pfet_03v3 L=1.963u W=0.419u nf=1 ad='int((nf+1)/2) * W/nf * 0.18u' as='int((nf+2)/2) * W/nf * 0.18u' pd='2*int((nf+1)/2) * (W/nf + 0.18u)' ps='2*int((nf+2)/2) * (W/nf + 0.18u)' nrd='0.18u / W' nrs='0.18u / W' sa=0 sb=0 sd=0
VO_m249 m249o Vmem 0
XR_m250 m250r m250r Vdd Vdd pfet_03v3 L=0.684u W=0.623u nf=1 ad='int((nf+1)/2) * W/nf * 0.18u' as='int((nf+2)/2) * W/nf * 0.18u' pd='2*int((nf+1)/2) * (W/nf + 0.18u)' ps='2*int((nf+2)/2) * (W/nf + 0.18u)' nrd='0.18u / W' nrs='0.18u / W' sa=0 sb=0 sd=0
VR_m250 nref m250r 0
XO_m250 m250o m250r Vdd Vdd pfet_03v3 L=0.467u W=1.595u nf=1 ad='int((nf+1)/2) * W/nf * 0.18u' as='int((nf+2)/2) * W/nf * 0.18u' pd='2*int((nf+1)/2) * (W/nf + 0.18u)' ps='2*int((nf+2)/2) * (W/nf + 0.18u)' nrd='0.18u / W' nrs='0.18u / W' sa=0 sb=0 sd=0
VO_m250 m250o Vmem 0
XR_m251 m251r m251r Vdd Vdd pfet_03v3 L=1.242u W=3.177u nf=1 ad='int((nf+1)/2) * W/nf * 0.18u' as='int((nf+2)/2) * W/nf * 0.18u' pd='2*int((nf+1)/2) * (W/nf + 0.18u)' ps='2*int((nf+2)/2) * (W/nf + 0.18u)' nrd='0.18u / W' nrs='0.18u / W' sa=0 sb=0 sd=0
VR_m251 nref m251r 0
XO_m251 m251o m251r Vdd Vdd pfet_03v3 L=3.564u W=1.101u nf=1 ad='int((nf+1)/2) * W/nf * 0.18u' as='int((nf+2)/2) * W/nf * 0.18u' pd='2*int((nf+1)/2) * (W/nf + 0.18u)' ps='2*int((nf+2)/2) * (W/nf + 0.18u)' nrd='0.18u / W' nrs='0.18u / W' sa=0 sb=0 sd=0
VO_m251 m251o Vmem 0
XR_m252 m252r m252r Vdd Vdd pfet_03v3 L=1.178u W=0.951u nf=1 ad='int((nf+1)/2) * W/nf * 0.18u' as='int((nf+2)/2) * W/nf * 0.18u' pd='2*int((nf+1)/2) * (W/nf + 0.18u)' ps='2*int((nf+2)/2) * (W/nf + 0.18u)' nrd='0.18u / W' nrs='0.18u / W' sa=0 sb=0 sd=0
VR_m252 nref m252r 0
XO_m252 m252o m252r Vdd Vdd pfet_03v3 L=4.362u W=1.621u nf=1 ad='int((nf+1)/2) * W/nf * 0.18u' as='int((nf+2)/2) * W/nf * 0.18u' pd='2*int((nf+1)/2) * (W/nf + 0.18u)' ps='2*int((nf+2)/2) * (W/nf + 0.18u)' nrd='0.18u / W' nrs='0.18u / W' sa=0 sb=0 sd=0
VO_m252 m252o Vmem 0
XR_m253 m253r m253r Vdd Vdd pfet_03v3 L=0.298u W=1.181u nf=1 ad='int((nf+1)/2) * W/nf * 0.18u' as='int((nf+2)/2) * W/nf * 0.18u' pd='2*int((nf+1)/2) * (W/nf + 0.18u)' ps='2*int((nf+2)/2) * (W/nf + 0.18u)' nrd='0.18u / W' nrs='0.18u / W' sa=0 sb=0 sd=0
VR_m253 nref m253r 0
XO_m253 m253o m253r Vdd Vdd pfet_03v3 L=3.825u W=0.302u nf=1 ad='int((nf+1)/2) * W/nf * 0.18u' as='int((nf+2)/2) * W/nf * 0.18u' pd='2*int((nf+1)/2) * (W/nf + 0.18u)' ps='2*int((nf+2)/2) * (W/nf + 0.18u)' nrd='0.18u / W' nrs='0.18u / W' sa=0 sb=0 sd=0
VO_m253 m253o Vmem 0
XR_m254 m254r m254r Vdd Vdd pfet_03v3 L=0.492u W=2.644u nf=1 ad='int((nf+1)/2) * W/nf * 0.18u' as='int((nf+2)/2) * W/nf * 0.18u' pd='2*int((nf+1)/2) * (W/nf + 0.18u)' ps='2*int((nf+2)/2) * (W/nf + 0.18u)' nrd='0.18u / W' nrs='0.18u / W' sa=0 sb=0 sd=0
VR_m254 nref m254r 0
XO_m254 m254o m254r Vdd Vdd pfet_03v3 L=7.701u W=1.518u nf=1 ad='int((nf+1)/2) * W/nf * 0.18u' as='int((nf+2)/2) * W/nf * 0.18u' pd='2*int((nf+1)/2) * (W/nf + 0.18u)' ps='2*int((nf+2)/2) * (W/nf + 0.18u)' nrd='0.18u / W' nrs='0.18u / W' sa=0 sb=0 sd=0
VO_m254 m254o Vmem 0
XR_m255 m255r m255r Vdd Vdd pfet_03v3 L=0.316u W=2.063u nf=1 ad='int((nf+1)/2) * W/nf * 0.18u' as='int((nf+2)/2) * W/nf * 0.18u' pd='2*int((nf+1)/2) * (W/nf + 0.18u)' ps='2*int((nf+2)/2) * (W/nf + 0.18u)' nrd='0.18u / W' nrs='0.18u / W' sa=0 sb=0 sd=0
VR_m255 nref m255r 0
XO_m255 m255o m255r Vdd Vdd pfet_03v3 L=1.453u W=3.313u nf=1 ad='int((nf+1)/2) * W/nf * 0.18u' as='int((nf+2)/2) * W/nf * 0.18u' pd='2*int((nf+1)/2) * (W/nf + 0.18u)' ps='2*int((nf+2)/2) * (W/nf + 0.18u)' nrd='0.18u / W' nrs='0.18u / W' sa=0 sb=0 sd=0
VO_m255 m255o Vmem 0
XR_m256 m256r m256r Vdd Vdd pfet_03v3 L=2.76u W=0.228u nf=1 ad='int((nf+1)/2) * W/nf * 0.18u' as='int((nf+2)/2) * W/nf * 0.18u' pd='2*int((nf+1)/2) * (W/nf + 0.18u)' ps='2*int((nf+2)/2) * (W/nf + 0.18u)' nrd='0.18u / W' nrs='0.18u / W' sa=0 sb=0 sd=0
VR_m256 nref m256r 0
XO_m256 m256o m256r Vdd Vdd pfet_03v3 L=4.364u W=2.521u nf=1 ad='int((nf+1)/2) * W/nf * 0.18u' as='int((nf+2)/2) * W/nf * 0.18u' pd='2*int((nf+1)/2) * (W/nf + 0.18u)' ps='2*int((nf+2)/2) * (W/nf + 0.18u)' nrd='0.18u / W' nrs='0.18u / W' sa=0 sb=0 sd=0
VO_m256 m256o Vmem 0
XR_m257 m257r m257r Vdd Vdd pfet_03v3 L=3.824u W=0.298u nf=1 ad='int((nf+1)/2) * W/nf * 0.18u' as='int((nf+2)/2) * W/nf * 0.18u' pd='2*int((nf+1)/2) * (W/nf + 0.18u)' ps='2*int((nf+2)/2) * (W/nf + 0.18u)' nrd='0.18u / W' nrs='0.18u / W' sa=0 sb=0 sd=0
VR_m257 nref m257r 0
XO_m257 m257o m257r Vdd Vdd pfet_03v3 L=3.187u W=1.242u nf=1 ad='int((nf+1)/2) * W/nf * 0.18u' as='int((nf+2)/2) * W/nf * 0.18u' pd='2*int((nf+1)/2) * (W/nf + 0.18u)' ps='2*int((nf+2)/2) * (W/nf + 0.18u)' nrd='0.18u / W' nrs='0.18u / W' sa=0 sb=0 sd=0
VO_m257 m257o Vmem 0
XR_m258 m258r m258r Vdd Vdd pfet_03v3 L=3.002u W=0.261u nf=1 ad='int((nf+1)/2) * W/nf * 0.18u' as='int((nf+2)/2) * W/nf * 0.18u' pd='2*int((nf+1)/2) * (W/nf + 0.18u)' ps='2*int((nf+2)/2) * (W/nf + 0.18u)' nrd='0.18u / W' nrs='0.18u / W' sa=0 sb=0 sd=0
VR_m258 nref m258r 0
XO_m258 m258o m258r Vdd Vdd pfet_03v3 L=0.796u W=3.78u nf=1 ad='int((nf+1)/2) * W/nf * 0.18u' as='int((nf+2)/2) * W/nf * 0.18u' pd='2*int((nf+1)/2) * (W/nf + 0.18u)' ps='2*int((nf+2)/2) * (W/nf + 0.18u)' nrd='0.18u / W' nrs='0.18u / W' sa=0 sb=0 sd=0
VO_m258 m258o Vmem 0
XR_m259 m259r m259r Vdd Vdd pfet_03v3 L=0.642u W=3.015u nf=1 ad='int((nf+1)/2) * W/nf * 0.18u' as='int((nf+2)/2) * W/nf * 0.18u' pd='2*int((nf+1)/2) * (W/nf + 0.18u)' ps='2*int((nf+2)/2) * (W/nf + 0.18u)' nrd='0.18u / W' nrs='0.18u / W' sa=0 sb=0 sd=0
VR_m259 nref m259r 0
XO_m259 m259o m259r Vdd Vdd pfet_03v3 L=0.459u W=0.252u nf=1 ad='int((nf+1)/2) * W/nf * 0.18u' as='int((nf+2)/2) * W/nf * 0.18u' pd='2*int((nf+1)/2) * (W/nf + 0.18u)' ps='2*int((nf+2)/2) * (W/nf + 0.18u)' nrd='0.18u / W' nrs='0.18u / W' sa=0 sb=0 sd=0
VO_m259 m259o Vmem 0
XR_m260 m260r m260r Vdd Vdd pfet_03v3 L=0.913u W=0.858u nf=1 ad='int((nf+1)/2) * W/nf * 0.18u' as='int((nf+2)/2) * W/nf * 0.18u' pd='2*int((nf+1)/2) * (W/nf + 0.18u)' ps='2*int((nf+2)/2) * (W/nf + 0.18u)' nrd='0.18u / W' nrs='0.18u / W' sa=0 sb=0 sd=0
VR_m260 nref m260r 0
XO_m260 m260o m260r Vdd Vdd pfet_03v3 L=3.433u W=2.091u nf=1 ad='int((nf+1)/2) * W/nf * 0.18u' as='int((nf+2)/2) * W/nf * 0.18u' pd='2*int((nf+1)/2) * (W/nf + 0.18u)' ps='2*int((nf+2)/2) * (W/nf + 0.18u)' nrd='0.18u / W' nrs='0.18u / W' sa=0 sb=0 sd=0
VO_m260 m260o Vmem 0
XR_m261 m261r m261r Vdd Vdd pfet_03v3 L=0.928u W=0.52u nf=1 ad='int((nf+1)/2) * W/nf * 0.18u' as='int((nf+2)/2) * W/nf * 0.18u' pd='2*int((nf+1)/2) * (W/nf + 0.18u)' ps='2*int((nf+2)/2) * (W/nf + 0.18u)' nrd='0.18u / W' nrs='0.18u / W' sa=0 sb=0 sd=0
VR_m261 nref m261r 0
XO_m261 m261o m261r Vdd Vdd pfet_03v3 L=1.423u W=0.243u nf=1 ad='int((nf+1)/2) * W/nf * 0.18u' as='int((nf+2)/2) * W/nf * 0.18u' pd='2*int((nf+1)/2) * (W/nf + 0.18u)' ps='2*int((nf+2)/2) * (W/nf + 0.18u)' nrd='0.18u / W' nrs='0.18u / W' sa=0 sb=0 sd=0
VO_m261 m261o Vmem 0
XR_m262 m262r m262r Vdd Vdd pfet_03v3 L=0.4u W=0.401u nf=1 ad='int((nf+1)/2) * W/nf * 0.18u' as='int((nf+2)/2) * W/nf * 0.18u' pd='2*int((nf+1)/2) * (W/nf + 0.18u)' ps='2*int((nf+2)/2) * (W/nf + 0.18u)' nrd='0.18u / W' nrs='0.18u / W' sa=0 sb=0 sd=0
VR_m262 nref m262r 0
XO_m262 m262o m262r Vdd Vdd pfet_03v3 L=1.586u W=0.381u nf=1 ad='int((nf+1)/2) * W/nf * 0.18u' as='int((nf+2)/2) * W/nf * 0.18u' pd='2*int((nf+1)/2) * (W/nf + 0.18u)' ps='2*int((nf+2)/2) * (W/nf + 0.18u)' nrd='0.18u / W' nrs='0.18u / W' sa=0 sb=0 sd=0
VO_m262 m262o Vmem 0
XR_m263 m263r m263r Vdd Vdd pfet_03v3 L=1.704u W=2.984u nf=1 ad='int((nf+1)/2) * W/nf * 0.18u' as='int((nf+2)/2) * W/nf * 0.18u' pd='2*int((nf+1)/2) * (W/nf + 0.18u)' ps='2*int((nf+2)/2) * (W/nf + 0.18u)' nrd='0.18u / W' nrs='0.18u / W' sa=0 sb=0 sd=0
VR_m263 nref m263r 0
XO_m263 m263o m263r Vdd Vdd pfet_03v3 L=0.404u W=1.9u nf=1 ad='int((nf+1)/2) * W/nf * 0.18u' as='int((nf+2)/2) * W/nf * 0.18u' pd='2*int((nf+1)/2) * (W/nf + 0.18u)' ps='2*int((nf+2)/2) * (W/nf + 0.18u)' nrd='0.18u / W' nrs='0.18u / W' sa=0 sb=0 sd=0
VO_m263 m263o Vmem 0
XR_m264 m264r m264r Vdd Vdd pfet_03v3 L=1.857u W=0.99u nf=1 ad='int((nf+1)/2) * W/nf * 0.18u' as='int((nf+2)/2) * W/nf * 0.18u' pd='2*int((nf+1)/2) * (W/nf + 0.18u)' ps='2*int((nf+2)/2) * (W/nf + 0.18u)' nrd='0.18u / W' nrs='0.18u / W' sa=0 sb=0 sd=0
VR_m264 nref m264r 0
XO_m264 m264o m264r Vdd Vdd pfet_03v3 L=0.336u W=0.916u nf=1 ad='int((nf+1)/2) * W/nf * 0.18u' as='int((nf+2)/2) * W/nf * 0.18u' pd='2*int((nf+1)/2) * (W/nf + 0.18u)' ps='2*int((nf+2)/2) * (W/nf + 0.18u)' nrd='0.18u / W' nrs='0.18u / W' sa=0 sb=0 sd=0
VO_m264 m264o Vmem 0
XR_m265 m265r m265r Vdd Vdd pfet_03v3 L=1.133u W=0.333u nf=1 ad='int((nf+1)/2) * W/nf * 0.18u' as='int((nf+2)/2) * W/nf * 0.18u' pd='2*int((nf+1)/2) * (W/nf + 0.18u)' ps='2*int((nf+2)/2) * (W/nf + 0.18u)' nrd='0.18u / W' nrs='0.18u / W' sa=0 sb=0 sd=0
VR_m265 nref m265r 0
XO_m265 m265o m265r Vdd Vdd pfet_03v3 L=3.549u W=0.304u nf=1 ad='int((nf+1)/2) * W/nf * 0.18u' as='int((nf+2)/2) * W/nf * 0.18u' pd='2*int((nf+1)/2) * (W/nf + 0.18u)' ps='2*int((nf+2)/2) * (W/nf + 0.18u)' nrd='0.18u / W' nrs='0.18u / W' sa=0 sb=0 sd=0
VO_m265 m265o Vmem 0
XR_m266 m266r m266r Vdd Vdd pfet_03v3 L=1.873u W=0.343u nf=1 ad='int((nf+1)/2) * W/nf * 0.18u' as='int((nf+2)/2) * W/nf * 0.18u' pd='2*int((nf+1)/2) * (W/nf + 0.18u)' ps='2*int((nf+2)/2) * (W/nf + 0.18u)' nrd='0.18u / W' nrs='0.18u / W' sa=0 sb=0 sd=0
VR_m266 nref m266r 0
XO_m266 m266o m266r Vdd Vdd pfet_03v3 L=0.421u W=1.024u nf=1 ad='int((nf+1)/2) * W/nf * 0.18u' as='int((nf+2)/2) * W/nf * 0.18u' pd='2*int((nf+1)/2) * (W/nf + 0.18u)' ps='2*int((nf+2)/2) * (W/nf + 0.18u)' nrd='0.18u / W' nrs='0.18u / W' sa=0 sb=0 sd=0
VO_m266 m266o Vmem 0
XR_m267 m267r m267r Vdd Vdd pfet_03v3 L=1.627u W=3.307u nf=1 ad='int((nf+1)/2) * W/nf * 0.18u' as='int((nf+2)/2) * W/nf * 0.18u' pd='2*int((nf+1)/2) * (W/nf + 0.18u)' ps='2*int((nf+2)/2) * (W/nf + 0.18u)' nrd='0.18u / W' nrs='0.18u / W' sa=0 sb=0 sd=0
VR_m267 nref m267r 0
XO_m267 m267o m267r Vdd Vdd pfet_03v3 L=0.931u W=0.427u nf=1 ad='int((nf+1)/2) * W/nf * 0.18u' as='int((nf+2)/2) * W/nf * 0.18u' pd='2*int((nf+1)/2) * (W/nf + 0.18u)' ps='2*int((nf+2)/2) * (W/nf + 0.18u)' nrd='0.18u / W' nrs='0.18u / W' sa=0 sb=0 sd=0
VO_m267 m267o Vmem 0
XR_m268 m268r m268r Vdd Vdd pfet_03v3 L=0.288u W=0.348u nf=1 ad='int((nf+1)/2) * W/nf * 0.18u' as='int((nf+2)/2) * W/nf * 0.18u' pd='2*int((nf+1)/2) * (W/nf + 0.18u)' ps='2*int((nf+2)/2) * (W/nf + 0.18u)' nrd='0.18u / W' nrs='0.18u / W' sa=0 sb=0 sd=0
VR_m268 nref m268r 0
XO_m268 m268o m268r Vdd Vdd pfet_03v3 L=1.758u W=0.636u nf=1 ad='int((nf+1)/2) * W/nf * 0.18u' as='int((nf+2)/2) * W/nf * 0.18u' pd='2*int((nf+1)/2) * (W/nf + 0.18u)' ps='2*int((nf+2)/2) * (W/nf + 0.18u)' nrd='0.18u / W' nrs='0.18u / W' sa=0 sb=0 sd=0
VO_m268 m268o Vmem 0
XR_m269 m269r m269r Vdd Vdd pfet_03v3 L=0.978u W=0.93u nf=1 ad='int((nf+1)/2) * W/nf * 0.18u' as='int((nf+2)/2) * W/nf * 0.18u' pd='2*int((nf+1)/2) * (W/nf + 0.18u)' ps='2*int((nf+2)/2) * (W/nf + 0.18u)' nrd='0.18u / W' nrs='0.18u / W' sa=0 sb=0 sd=0
VR_m269 nref m269r 0
XO_m269 m269o m269r Vdd Vdd pfet_03v3 L=4.053u W=0.282u nf=1 ad='int((nf+1)/2) * W/nf * 0.18u' as='int((nf+2)/2) * W/nf * 0.18u' pd='2*int((nf+1)/2) * (W/nf + 0.18u)' ps='2*int((nf+2)/2) * (W/nf + 0.18u)' nrd='0.18u / W' nrs='0.18u / W' sa=0 sb=0 sd=0
VO_m269 m269o Vmem 0
XR_m270 m270r m270r Vdd Vdd pfet_03v3 L=0.693u W=2.297u nf=1 ad='int((nf+1)/2) * W/nf * 0.18u' as='int((nf+2)/2) * W/nf * 0.18u' pd='2*int((nf+1)/2) * (W/nf + 0.18u)' ps='2*int((nf+2)/2) * (W/nf + 0.18u)' nrd='0.18u / W' nrs='0.18u / W' sa=0 sb=0 sd=0
VR_m270 nref m270r 0
XO_m270 m270o m270r Vdd Vdd pfet_03v3 L=2.404u W=2.928u nf=1 ad='int((nf+1)/2) * W/nf * 0.18u' as='int((nf+2)/2) * W/nf * 0.18u' pd='2*int((nf+1)/2) * (W/nf + 0.18u)' ps='2*int((nf+2)/2) * (W/nf + 0.18u)' nrd='0.18u / W' nrs='0.18u / W' sa=0 sb=0 sd=0
VO_m270 m270o Vmem 0
XR_m271 m271r m271r Vdd Vdd pfet_03v3 L=1.279u W=0.896u nf=1 ad='int((nf+1)/2) * W/nf * 0.18u' as='int((nf+2)/2) * W/nf * 0.18u' pd='2*int((nf+1)/2) * (W/nf + 0.18u)' ps='2*int((nf+2)/2) * (W/nf + 0.18u)' nrd='0.18u / W' nrs='0.18u / W' sa=0 sb=0 sd=0
VR_m271 nref m271r 0
XO_m271 m271o m271r Vdd Vdd pfet_03v3 L=4.374u W=0.276u nf=1 ad='int((nf+1)/2) * W/nf * 0.18u' as='int((nf+2)/2) * W/nf * 0.18u' pd='2*int((nf+1)/2) * (W/nf + 0.18u)' ps='2*int((nf+2)/2) * (W/nf + 0.18u)' nrd='0.18u / W' nrs='0.18u / W' sa=0 sb=0 sd=0
VO_m271 m271o Vmem 0
XR_m272 m272r m272r Vdd Vdd pfet_03v3 L=0.709u W=0.599u nf=1 ad='int((nf+1)/2) * W/nf * 0.18u' as='int((nf+2)/2) * W/nf * 0.18u' pd='2*int((nf+1)/2) * (W/nf + 0.18u)' ps='2*int((nf+2)/2) * (W/nf + 0.18u)' nrd='0.18u / W' nrs='0.18u / W' sa=0 sb=0 sd=0
VR_m272 nref m272r 0
XO_m272 m272o m272r Vdd Vdd pfet_03v3 L=0.913u W=0.837u nf=1 ad='int((nf+1)/2) * W/nf * 0.18u' as='int((nf+2)/2) * W/nf * 0.18u' pd='2*int((nf+1)/2) * (W/nf + 0.18u)' ps='2*int((nf+2)/2) * (W/nf + 0.18u)' nrd='0.18u / W' nrs='0.18u / W' sa=0 sb=0 sd=0
VO_m272 m272o Vmem 0
XR_m273 m273r m273r Vdd Vdd pfet_03v3 L=0.321u W=3.133u nf=1 ad='int((nf+1)/2) * W/nf * 0.18u' as='int((nf+2)/2) * W/nf * 0.18u' pd='2*int((nf+1)/2) * (W/nf + 0.18u)' ps='2*int((nf+2)/2) * (W/nf + 0.18u)' nrd='0.18u / W' nrs='0.18u / W' sa=0 sb=0 sd=0
VR_m273 nref m273r 0
XO_m273 m273o m273r Vdd Vdd pfet_03v3 L=2.78u W=0.4u nf=1 ad='int((nf+1)/2) * W/nf * 0.18u' as='int((nf+2)/2) * W/nf * 0.18u' pd='2*int((nf+1)/2) * (W/nf + 0.18u)' ps='2*int((nf+2)/2) * (W/nf + 0.18u)' nrd='0.18u / W' nrs='0.18u / W' sa=0 sb=0 sd=0
VO_m273 m273o Vmem 0
XR_m274 m274r m274r Vdd Vdd pfet_03v3 L=0.374u W=1.234u nf=1 ad='int((nf+1)/2) * W/nf * 0.18u' as='int((nf+2)/2) * W/nf * 0.18u' pd='2*int((nf+1)/2) * (W/nf + 0.18u)' ps='2*int((nf+2)/2) * (W/nf + 0.18u)' nrd='0.18u / W' nrs='0.18u / W' sa=0 sb=0 sd=0
VR_m274 nref m274r 0
XO_m274 m274o m274r Vdd Vdd pfet_03v3 L=0.72u W=0.317u nf=1 ad='int((nf+1)/2) * W/nf * 0.18u' as='int((nf+2)/2) * W/nf * 0.18u' pd='2*int((nf+1)/2) * (W/nf + 0.18u)' ps='2*int((nf+2)/2) * (W/nf + 0.18u)' nrd='0.18u / W' nrs='0.18u / W' sa=0 sb=0 sd=0
VO_m274 m274o Vmem 0
XR_m275 m275r m275r Vdd Vdd pfet_03v3 L=0.787u W=0.495u nf=1 ad='int((nf+1)/2) * W/nf * 0.18u' as='int((nf+2)/2) * W/nf * 0.18u' pd='2*int((nf+1)/2) * (W/nf + 0.18u)' ps='2*int((nf+2)/2) * (W/nf + 0.18u)' nrd='0.18u / W' nrs='0.18u / W' sa=0 sb=0 sd=0
VR_m275 nref m275r 0
XO_m275 m275o m275r Vdd Vdd pfet_03v3 L=1.832u W=1.872u nf=1 ad='int((nf+1)/2) * W/nf * 0.18u' as='int((nf+2)/2) * W/nf * 0.18u' pd='2*int((nf+1)/2) * (W/nf + 0.18u)' ps='2*int((nf+2)/2) * (W/nf + 0.18u)' nrd='0.18u / W' nrs='0.18u / W' sa=0 sb=0 sd=0
VO_m275 m275o Vmem 0
XR_m276 m276r m276r Vdd Vdd pfet_03v3 L=0.647u W=1.715u nf=1 ad='int((nf+1)/2) * W/nf * 0.18u' as='int((nf+2)/2) * W/nf * 0.18u' pd='2*int((nf+1)/2) * (W/nf + 0.18u)' ps='2*int((nf+2)/2) * (W/nf + 0.18u)' nrd='0.18u / W' nrs='0.18u / W' sa=0 sb=0 sd=0
VR_m276 nref m276r 0
XO_m276 m276o m276r Vdd Vdd pfet_03v3 L=1.918u W=3.98u nf=1 ad='int((nf+1)/2) * W/nf * 0.18u' as='int((nf+2)/2) * W/nf * 0.18u' pd='2*int((nf+1)/2) * (W/nf + 0.18u)' ps='2*int((nf+2)/2) * (W/nf + 0.18u)' nrd='0.18u / W' nrs='0.18u / W' sa=0 sb=0 sd=0
VO_m276 m276o Vmem 0
XR_m277 m277r m277r Vdd Vdd pfet_03v3 L=1.006u W=2u nf=1 ad='int((nf+1)/2) * W/nf * 0.18u' as='int((nf+2)/2) * W/nf * 0.18u' pd='2*int((nf+1)/2) * (W/nf + 0.18u)' ps='2*int((nf+2)/2) * (W/nf + 0.18u)' nrd='0.18u / W' nrs='0.18u / W' sa=0 sb=0 sd=0
VR_m277 nref m277r 0
XO_m277 m277o m277r Vdd Vdd pfet_03v3 L=0.509u W=0.315u nf=1 ad='int((nf+1)/2) * W/nf * 0.18u' as='int((nf+2)/2) * W/nf * 0.18u' pd='2*int((nf+1)/2) * (W/nf + 0.18u)' ps='2*int((nf+2)/2) * (W/nf + 0.18u)' nrd='0.18u / W' nrs='0.18u / W' sa=0 sb=0 sd=0
VO_m277 m277o Vmem 0
XR_m278 m278r m278r Vdd Vdd pfet_03v3 L=0.437u W=2.429u nf=1 ad='int((nf+1)/2) * W/nf * 0.18u' as='int((nf+2)/2) * W/nf * 0.18u' pd='2*int((nf+1)/2) * (W/nf + 0.18u)' ps='2*int((nf+2)/2) * (W/nf + 0.18u)' nrd='0.18u / W' nrs='0.18u / W' sa=0 sb=0 sd=0
VR_m278 nref m278r 0
XO_m278 m278o m278r Vdd Vdd pfet_03v3 L=2.664u W=1.636u nf=1 ad='int((nf+1)/2) * W/nf * 0.18u' as='int((nf+2)/2) * W/nf * 0.18u' pd='2*int((nf+1)/2) * (W/nf + 0.18u)' ps='2*int((nf+2)/2) * (W/nf + 0.18u)' nrd='0.18u / W' nrs='0.18u / W' sa=0 sb=0 sd=0
VO_m278 m278o Vmem 0
XR_m279 m279r m279r Vdd Vdd pfet_03v3 L=2.514u W=0.388u nf=1 ad='int((nf+1)/2) * W/nf * 0.18u' as='int((nf+2)/2) * W/nf * 0.18u' pd='2*int((nf+1)/2) * (W/nf + 0.18u)' ps='2*int((nf+2)/2) * (W/nf + 0.18u)' nrd='0.18u / W' nrs='0.18u / W' sa=0 sb=0 sd=0
VR_m279 nref m279r 0
XO_m279 m279o m279r Vdd Vdd pfet_03v3 L=0.317u W=1.474u nf=1 ad='int((nf+1)/2) * W/nf * 0.18u' as='int((nf+2)/2) * W/nf * 0.18u' pd='2*int((nf+1)/2) * (W/nf + 0.18u)' ps='2*int((nf+2)/2) * (W/nf + 0.18u)' nrd='0.18u / W' nrs='0.18u / W' sa=0 sb=0 sd=0
VO_m279 m279o Vmem 0
XR_m280 m280r m280r Vdd Vdd pfet_03v3 L=0.723u W=0.619u nf=1 ad='int((nf+1)/2) * W/nf * 0.18u' as='int((nf+2)/2) * W/nf * 0.18u' pd='2*int((nf+1)/2) * (W/nf + 0.18u)' ps='2*int((nf+2)/2) * (W/nf + 0.18u)' nrd='0.18u / W' nrs='0.18u / W' sa=0 sb=0 sd=0
VR_m280 nref m280r 0
XO_m280 m280o m280r Vdd Vdd pfet_03v3 L=5.858u W=0.525u nf=1 ad='int((nf+1)/2) * W/nf * 0.18u' as='int((nf+2)/2) * W/nf * 0.18u' pd='2*int((nf+1)/2) * (W/nf + 0.18u)' ps='2*int((nf+2)/2) * (W/nf + 0.18u)' nrd='0.18u / W' nrs='0.18u / W' sa=0 sb=0 sd=0
VO_m280 m280o Vmem 0
XR_m281 m281r m281r Vdd Vdd pfet_03v3 L=0.421u W=2.366u nf=1 ad='int((nf+1)/2) * W/nf * 0.18u' as='int((nf+2)/2) * W/nf * 0.18u' pd='2*int((nf+1)/2) * (W/nf + 0.18u)' ps='2*int((nf+2)/2) * (W/nf + 0.18u)' nrd='0.18u / W' nrs='0.18u / W' sa=0 sb=0 sd=0
VR_m281 nref m281r 0
XO_m281 m281o m281r Vdd Vdd pfet_03v3 L=0.444u W=0.269u nf=1 ad='int((nf+1)/2) * W/nf * 0.18u' as='int((nf+2)/2) * W/nf * 0.18u' pd='2*int((nf+1)/2) * (W/nf + 0.18u)' ps='2*int((nf+2)/2) * (W/nf + 0.18u)' nrd='0.18u / W' nrs='0.18u / W' sa=0 sb=0 sd=0
VO_m281 m281o Vmem 0
XR_m282 m282r m282r Vdd Vdd pfet_03v3 L=1.237u W=0.688u nf=1 ad='int((nf+1)/2) * W/nf * 0.18u' as='int((nf+2)/2) * W/nf * 0.18u' pd='2*int((nf+1)/2) * (W/nf + 0.18u)' ps='2*int((nf+2)/2) * (W/nf + 0.18u)' nrd='0.18u / W' nrs='0.18u / W' sa=0 sb=0 sd=0
VR_m282 nref m282r 0
XO_m282 m282o m282r Vdd Vdd pfet_03v3 L=1.76u W=1.823u nf=1 ad='int((nf+1)/2) * W/nf * 0.18u' as='int((nf+2)/2) * W/nf * 0.18u' pd='2*int((nf+1)/2) * (W/nf + 0.18u)' ps='2*int((nf+2)/2) * (W/nf + 0.18u)' nrd='0.18u / W' nrs='0.18u / W' sa=0 sb=0 sd=0
VO_m282 m282o Vmem 0
XR_m283 m283r m283r Vdd Vdd pfet_03v3 L=0.417u W=0.603u nf=1 ad='int((nf+1)/2) * W/nf * 0.18u' as='int((nf+2)/2) * W/nf * 0.18u' pd='2*int((nf+1)/2) * (W/nf + 0.18u)' ps='2*int((nf+2)/2) * (W/nf + 0.18u)' nrd='0.18u / W' nrs='0.18u / W' sa=0 sb=0 sd=0
VR_m283 nref m283r 0
XO_m283 m283o m283r Vdd Vdd pfet_03v3 L=4.156u W=0.628u nf=1 ad='int((nf+1)/2) * W/nf * 0.18u' as='int((nf+2)/2) * W/nf * 0.18u' pd='2*int((nf+1)/2) * (W/nf + 0.18u)' ps='2*int((nf+2)/2) * (W/nf + 0.18u)' nrd='0.18u / W' nrs='0.18u / W' sa=0 sb=0 sd=0
VO_m283 m283o Vmem 0
XR_m284 m284r m284r Vdd Vdd pfet_03v3 L=1.73u W=0.835u nf=1 ad='int((nf+1)/2) * W/nf * 0.18u' as='int((nf+2)/2) * W/nf * 0.18u' pd='2*int((nf+1)/2) * (W/nf + 0.18u)' ps='2*int((nf+2)/2) * (W/nf + 0.18u)' nrd='0.18u / W' nrs='0.18u / W' sa=0 sb=0 sd=0
VR_m284 nref m284r 0
XO_m284 m284o m284r Vdd Vdd pfet_03v3 L=0.781u W=0.597u nf=1 ad='int((nf+1)/2) * W/nf * 0.18u' as='int((nf+2)/2) * W/nf * 0.18u' pd='2*int((nf+1)/2) * (W/nf + 0.18u)' ps='2*int((nf+2)/2) * (W/nf + 0.18u)' nrd='0.18u / W' nrs='0.18u / W' sa=0 sb=0 sd=0
VO_m284 m284o Vmem 0
XR_m285 m285r m285r Vdd Vdd pfet_03v3 L=0.35u W=0.93u nf=1 ad='int((nf+1)/2) * W/nf * 0.18u' as='int((nf+2)/2) * W/nf * 0.18u' pd='2*int((nf+1)/2) * (W/nf + 0.18u)' ps='2*int((nf+2)/2) * (W/nf + 0.18u)' nrd='0.18u / W' nrs='0.18u / W' sa=0 sb=0 sd=0
VR_m285 nref m285r 0
XO_m285 m285o m285r Vdd Vdd pfet_03v3 L=6.071u W=1.879u nf=1 ad='int((nf+1)/2) * W/nf * 0.18u' as='int((nf+2)/2) * W/nf * 0.18u' pd='2*int((nf+1)/2) * (W/nf + 0.18u)' ps='2*int((nf+2)/2) * (W/nf + 0.18u)' nrd='0.18u / W' nrs='0.18u / W' sa=0 sb=0 sd=0
VO_m285 m285o Vmem 0
XR_m286 m286r m286r Vdd Vdd pfet_03v3 L=1.951u W=0.981u nf=1 ad='int((nf+1)/2) * W/nf * 0.18u' as='int((nf+2)/2) * W/nf * 0.18u' pd='2*int((nf+1)/2) * (W/nf + 0.18u)' ps='2*int((nf+2)/2) * (W/nf + 0.18u)' nrd='0.18u / W' nrs='0.18u / W' sa=0 sb=0 sd=0
VR_m286 nref m286r 0
XO_m286 m286o m286r Vdd Vdd pfet_03v3 L=3.697u W=0.954u nf=1 ad='int((nf+1)/2) * W/nf * 0.18u' as='int((nf+2)/2) * W/nf * 0.18u' pd='2*int((nf+1)/2) * (W/nf + 0.18u)' ps='2*int((nf+2)/2) * (W/nf + 0.18u)' nrd='0.18u / W' nrs='0.18u / W' sa=0 sb=0 sd=0
VO_m286 m286o Vmem 0
XR_m287 m287r m287r Vdd Vdd pfet_03v3 L=3.302u W=0.507u nf=1 ad='int((nf+1)/2) * W/nf * 0.18u' as='int((nf+2)/2) * W/nf * 0.18u' pd='2*int((nf+1)/2) * (W/nf + 0.18u)' ps='2*int((nf+2)/2) * (W/nf + 0.18u)' nrd='0.18u / W' nrs='0.18u / W' sa=0 sb=0 sd=0
VR_m287 nref m287r 0
XO_m287 m287o m287r Vdd Vdd pfet_03v3 L=3.306u W=3.007u nf=1 ad='int((nf+1)/2) * W/nf * 0.18u' as='int((nf+2)/2) * W/nf * 0.18u' pd='2*int((nf+1)/2) * (W/nf + 0.18u)' ps='2*int((nf+2)/2) * (W/nf + 0.18u)' nrd='0.18u / W' nrs='0.18u / W' sa=0 sb=0 sd=0
VO_m287 m287o Vmem 0
XR_m288 m288r m288r Vdd Vdd pfet_03v3 L=0.44u W=0.336u nf=1 ad='int((nf+1)/2) * W/nf * 0.18u' as='int((nf+2)/2) * W/nf * 0.18u' pd='2*int((nf+1)/2) * (W/nf + 0.18u)' ps='2*int((nf+2)/2) * (W/nf + 0.18u)' nrd='0.18u / W' nrs='0.18u / W' sa=0 sb=0 sd=0
VR_m288 nref m288r 0
XO_m288 m288o m288r Vdd Vdd pfet_03v3 L=4.239u W=0.532u nf=1 ad='int((nf+1)/2) * W/nf * 0.18u' as='int((nf+2)/2) * W/nf * 0.18u' pd='2*int((nf+1)/2) * (W/nf + 0.18u)' ps='2*int((nf+2)/2) * (W/nf + 0.18u)' nrd='0.18u / W' nrs='0.18u / W' sa=0 sb=0 sd=0
VO_m288 m288o Vmem 0
XR_m289 m289r m289r Vdd Vdd pfet_03v3 L=2.356u W=0.238u nf=1 ad='int((nf+1)/2) * W/nf * 0.18u' as='int((nf+2)/2) * W/nf * 0.18u' pd='2*int((nf+1)/2) * (W/nf + 0.18u)' ps='2*int((nf+2)/2) * (W/nf + 0.18u)' nrd='0.18u / W' nrs='0.18u / W' sa=0 sb=0 sd=0
VR_m289 nref m289r 0
XO_m289 m289o m289r Vdd Vdd pfet_03v3 L=0.465u W=1.985u nf=1 ad='int((nf+1)/2) * W/nf * 0.18u' as='int((nf+2)/2) * W/nf * 0.18u' pd='2*int((nf+1)/2) * (W/nf + 0.18u)' ps='2*int((nf+2)/2) * (W/nf + 0.18u)' nrd='0.18u / W' nrs='0.18u / W' sa=0 sb=0 sd=0
VO_m289 m289o Vmem 0
XR_m290 m290r m290r Vdd Vdd pfet_03v3 L=0.783u W=1.575u nf=1 ad='int((nf+1)/2) * W/nf * 0.18u' as='int((nf+2)/2) * W/nf * 0.18u' pd='2*int((nf+1)/2) * (W/nf + 0.18u)' ps='2*int((nf+2)/2) * (W/nf + 0.18u)' nrd='0.18u / W' nrs='0.18u / W' sa=0 sb=0 sd=0
VR_m290 nref m290r 0
XO_m290 m290o m290r Vdd Vdd pfet_03v3 L=5.801u W=0.477u nf=1 ad='int((nf+1)/2) * W/nf * 0.18u' as='int((nf+2)/2) * W/nf * 0.18u' pd='2*int((nf+1)/2) * (W/nf + 0.18u)' ps='2*int((nf+2)/2) * (W/nf + 0.18u)' nrd='0.18u / W' nrs='0.18u / W' sa=0 sb=0 sd=0
VO_m290 m290o Vmem 0
XR_m291 m291r m291r Vdd Vdd pfet_03v3 L=2.21u W=0.319u nf=1 ad='int((nf+1)/2) * W/nf * 0.18u' as='int((nf+2)/2) * W/nf * 0.18u' pd='2*int((nf+1)/2) * (W/nf + 0.18u)' ps='2*int((nf+2)/2) * (W/nf + 0.18u)' nrd='0.18u / W' nrs='0.18u / W' sa=0 sb=0 sd=0
VR_m291 nref m291r 0
XO_m291 m291o m291r Vdd Vdd pfet_03v3 L=1.801u W=0.423u nf=1 ad='int((nf+1)/2) * W/nf * 0.18u' as='int((nf+2)/2) * W/nf * 0.18u' pd='2*int((nf+1)/2) * (W/nf + 0.18u)' ps='2*int((nf+2)/2) * (W/nf + 0.18u)' nrd='0.18u / W' nrs='0.18u / W' sa=0 sb=0 sd=0
VO_m291 m291o Vmem 0
XR_m292 m292r m292r Vdd Vdd pfet_03v3 L=2.754u W=1.348u nf=1 ad='int((nf+1)/2) * W/nf * 0.18u' as='int((nf+2)/2) * W/nf * 0.18u' pd='2*int((nf+1)/2) * (W/nf + 0.18u)' ps='2*int((nf+2)/2) * (W/nf + 0.18u)' nrd='0.18u / W' nrs='0.18u / W' sa=0 sb=0 sd=0
VR_m292 nref m292r 0
XO_m292 m292o m292r Vdd Vdd pfet_03v3 L=3.447u W=0.261u nf=1 ad='int((nf+1)/2) * W/nf * 0.18u' as='int((nf+2)/2) * W/nf * 0.18u' pd='2*int((nf+1)/2) * (W/nf + 0.18u)' ps='2*int((nf+2)/2) * (W/nf + 0.18u)' nrd='0.18u / W' nrs='0.18u / W' sa=0 sb=0 sd=0
VO_m292 m292o Vmem 0
XR_m293 m293r m293r Vdd Vdd pfet_03v3 L=2.824u W=1.014u nf=1 ad='int((nf+1)/2) * W/nf * 0.18u' as='int((nf+2)/2) * W/nf * 0.18u' pd='2*int((nf+1)/2) * (W/nf + 0.18u)' ps='2*int((nf+2)/2) * (W/nf + 0.18u)' nrd='0.18u / W' nrs='0.18u / W' sa=0 sb=0 sd=0
VR_m293 nref m293r 0
XO_m293 m293o m293r Vdd Vdd pfet_03v3 L=3.521u W=1.062u nf=1 ad='int((nf+1)/2) * W/nf * 0.18u' as='int((nf+2)/2) * W/nf * 0.18u' pd='2*int((nf+1)/2) * (W/nf + 0.18u)' ps='2*int((nf+2)/2) * (W/nf + 0.18u)' nrd='0.18u / W' nrs='0.18u / W' sa=0 sb=0 sd=0
VO_m293 m293o Vmem 0
XR_m294 m294r m294r Vdd Vdd pfet_03v3 L=0.371u W=0.449u nf=1 ad='int((nf+1)/2) * W/nf * 0.18u' as='int((nf+2)/2) * W/nf * 0.18u' pd='2*int((nf+1)/2) * (W/nf + 0.18u)' ps='2*int((nf+2)/2) * (W/nf + 0.18u)' nrd='0.18u / W' nrs='0.18u / W' sa=0 sb=0 sd=0
VR_m294 nref m294r 0
XO_m294 m294o m294r Vdd Vdd pfet_03v3 L=1.533u W=2.772u nf=1 ad='int((nf+1)/2) * W/nf * 0.18u' as='int((nf+2)/2) * W/nf * 0.18u' pd='2*int((nf+1)/2) * (W/nf + 0.18u)' ps='2*int((nf+2)/2) * (W/nf + 0.18u)' nrd='0.18u / W' nrs='0.18u / W' sa=0 sb=0 sd=0
VO_m294 m294o Vmem 0
XR_m295 m295r m295r Vdd Vdd pfet_03v3 L=1.918u W=1.502u nf=1 ad='int((nf+1)/2) * W/nf * 0.18u' as='int((nf+2)/2) * W/nf * 0.18u' pd='2*int((nf+1)/2) * (W/nf + 0.18u)' ps='2*int((nf+2)/2) * (W/nf + 0.18u)' nrd='0.18u / W' nrs='0.18u / W' sa=0 sb=0 sd=0
VR_m295 nref m295r 0
XO_m295 m295o m295r Vdd Vdd pfet_03v3 L=1.119u W=1.165u nf=1 ad='int((nf+1)/2) * W/nf * 0.18u' as='int((nf+2)/2) * W/nf * 0.18u' pd='2*int((nf+1)/2) * (W/nf + 0.18u)' ps='2*int((nf+2)/2) * (W/nf + 0.18u)' nrd='0.18u / W' nrs='0.18u / W' sa=0 sb=0 sd=0
VO_m295 m295o Vmem 0
XR_m296 m296r m296r Vdd Vdd pfet_03v3 L=1.447u W=0.926u nf=1 ad='int((nf+1)/2) * W/nf * 0.18u' as='int((nf+2)/2) * W/nf * 0.18u' pd='2*int((nf+1)/2) * (W/nf + 0.18u)' ps='2*int((nf+2)/2) * (W/nf + 0.18u)' nrd='0.18u / W' nrs='0.18u / W' sa=0 sb=0 sd=0
VR_m296 nref m296r 0
XO_m296 m296o m296r Vdd Vdd pfet_03v3 L=0.547u W=0.89u nf=1 ad='int((nf+1)/2) * W/nf * 0.18u' as='int((nf+2)/2) * W/nf * 0.18u' pd='2*int((nf+1)/2) * (W/nf + 0.18u)' ps='2*int((nf+2)/2) * (W/nf + 0.18u)' nrd='0.18u / W' nrs='0.18u / W' sa=0 sb=0 sd=0
VO_m296 m296o Vmem 0
XR_m297 m297r m297r Vdd Vdd pfet_03v3 L=1.981u W=2.856u nf=1 ad='int((nf+1)/2) * W/nf * 0.18u' as='int((nf+2)/2) * W/nf * 0.18u' pd='2*int((nf+1)/2) * (W/nf + 0.18u)' ps='2*int((nf+2)/2) * (W/nf + 0.18u)' nrd='0.18u / W' nrs='0.18u / W' sa=0 sb=0 sd=0
VR_m297 nref m297r 0
XO_m297 m297o m297r Vdd Vdd pfet_03v3 L=7.782u W=3.878u nf=1 ad='int((nf+1)/2) * W/nf * 0.18u' as='int((nf+2)/2) * W/nf * 0.18u' pd='2*int((nf+1)/2) * (W/nf + 0.18u)' ps='2*int((nf+2)/2) * (W/nf + 0.18u)' nrd='0.18u / W' nrs='0.18u / W' sa=0 sb=0 sd=0
VO_m297 m297o Vmem 0
XR_m298 m298r m298r Vdd Vdd pfet_03v3 L=0.741u W=0.969u nf=1 ad='int((nf+1)/2) * W/nf * 0.18u' as='int((nf+2)/2) * W/nf * 0.18u' pd='2*int((nf+1)/2) * (W/nf + 0.18u)' ps='2*int((nf+2)/2) * (W/nf + 0.18u)' nrd='0.18u / W' nrs='0.18u / W' sa=0 sb=0 sd=0
VR_m298 nref m298r 0
XO_m298 m298o m298r Vdd Vdd pfet_03v3 L=0.292u W=2.654u nf=1 ad='int((nf+1)/2) * W/nf * 0.18u' as='int((nf+2)/2) * W/nf * 0.18u' pd='2*int((nf+1)/2) * (W/nf + 0.18u)' ps='2*int((nf+2)/2) * (W/nf + 0.18u)' nrd='0.18u / W' nrs='0.18u / W' sa=0 sb=0 sd=0
VO_m298 m298o Vmem 0
XR_m299 m299r m299r Vdd Vdd pfet_03v3 L=0.52u W=0.298u nf=1 ad='int((nf+1)/2) * W/nf * 0.18u' as='int((nf+2)/2) * W/nf * 0.18u' pd='2*int((nf+1)/2) * (W/nf + 0.18u)' ps='2*int((nf+2)/2) * (W/nf + 0.18u)' nrd='0.18u / W' nrs='0.18u / W' sa=0 sb=0 sd=0
VR_m299 nref m299r 0
XO_m299 m299o m299r Vdd Vdd pfet_03v3 L=2.46u W=0.507u nf=1 ad='int((nf+1)/2) * W/nf * 0.18u' as='int((nf+2)/2) * W/nf * 0.18u' pd='2*int((nf+1)/2) * (W/nf + 0.18u)' ps='2*int((nf+2)/2) * (W/nf + 0.18u)' nrd='0.18u / W' nrs='0.18u / W' sa=0 sb=0 sd=0
VO_m299 m299o Vmem 0
XR_m300 m300r m300r Vdd Vdd pfet_03v3 L=1.176u W=0.301u nf=1 ad='int((nf+1)/2) * W/nf * 0.18u' as='int((nf+2)/2) * W/nf * 0.18u' pd='2*int((nf+1)/2) * (W/nf + 0.18u)' ps='2*int((nf+2)/2) * (W/nf + 0.18u)' nrd='0.18u / W' nrs='0.18u / W' sa=0 sb=0 sd=0
VR_m300 nref m300r 0
XO_m300 m300o m300r Vdd Vdd pfet_03v3 L=0.604u W=2.214u nf=1 ad='int((nf+1)/2) * W/nf * 0.18u' as='int((nf+2)/2) * W/nf * 0.18u' pd='2*int((nf+1)/2) * (W/nf + 0.18u)' ps='2*int((nf+2)/2) * (W/nf + 0.18u)' nrd='0.18u / W' nrs='0.18u / W' sa=0 sb=0 sd=0
VO_m300 m300o Vmem 0
XR_m301 m301r m301r Vdd Vdd pfet_03v3 L=1.421u W=0.473u nf=1 ad='int((nf+1)/2) * W/nf * 0.18u' as='int((nf+2)/2) * W/nf * 0.18u' pd='2*int((nf+1)/2) * (W/nf + 0.18u)' ps='2*int((nf+2)/2) * (W/nf + 0.18u)' nrd='0.18u / W' nrs='0.18u / W' sa=0 sb=0 sd=0
VR_m301 nref m301r 0
XO_m301 m301o m301r Vdd Vdd pfet_03v3 L=0.44u W=1.243u nf=1 ad='int((nf+1)/2) * W/nf * 0.18u' as='int((nf+2)/2) * W/nf * 0.18u' pd='2*int((nf+1)/2) * (W/nf + 0.18u)' ps='2*int((nf+2)/2) * (W/nf + 0.18u)' nrd='0.18u / W' nrs='0.18u / W' sa=0 sb=0 sd=0
VO_m301 m301o Vmem 0
XR_m302 m302r m302r Vdd Vdd pfet_03v3 L=0.828u W=0.27u nf=1 ad='int((nf+1)/2) * W/nf * 0.18u' as='int((nf+2)/2) * W/nf * 0.18u' pd='2*int((nf+1)/2) * (W/nf + 0.18u)' ps='2*int((nf+2)/2) * (W/nf + 0.18u)' nrd='0.18u / W' nrs='0.18u / W' sa=0 sb=0 sd=0
VR_m302 nref m302r 0
XO_m302 m302o m302r Vdd Vdd pfet_03v3 L=1.037u W=3.749u nf=1 ad='int((nf+1)/2) * W/nf * 0.18u' as='int((nf+2)/2) * W/nf * 0.18u' pd='2*int((nf+1)/2) * (W/nf + 0.18u)' ps='2*int((nf+2)/2) * (W/nf + 0.18u)' nrd='0.18u / W' nrs='0.18u / W' sa=0 sb=0 sd=0
VO_m302 m302o Vmem 0
XR_m303 m303r m303r Vdd Vdd pfet_03v3 L=3.569u W=0.619u nf=1 ad='int((nf+1)/2) * W/nf * 0.18u' as='int((nf+2)/2) * W/nf * 0.18u' pd='2*int((nf+1)/2) * (W/nf + 0.18u)' ps='2*int((nf+2)/2) * (W/nf + 0.18u)' nrd='0.18u / W' nrs='0.18u / W' sa=0 sb=0 sd=0
VR_m303 nref m303r 0
XO_m303 m303o m303r Vdd Vdd pfet_03v3 L=0.647u W=1.93u nf=1 ad='int((nf+1)/2) * W/nf * 0.18u' as='int((nf+2)/2) * W/nf * 0.18u' pd='2*int((nf+1)/2) * (W/nf + 0.18u)' ps='2*int((nf+2)/2) * (W/nf + 0.18u)' nrd='0.18u / W' nrs='0.18u / W' sa=0 sb=0 sd=0
VO_m303 m303o Vmem 0
XR_m304 m304r m304r Vdd Vdd pfet_03v3 L=1.739u W=0.4u nf=1 ad='int((nf+1)/2) * W/nf * 0.18u' as='int((nf+2)/2) * W/nf * 0.18u' pd='2*int((nf+1)/2) * (W/nf + 0.18u)' ps='2*int((nf+2)/2) * (W/nf + 0.18u)' nrd='0.18u / W' nrs='0.18u / W' sa=0 sb=0 sd=0
VR_m304 nref m304r 0
XO_m304 m304o m304r Vdd Vdd pfet_03v3 L=0.399u W=2.289u nf=1 ad='int((nf+1)/2) * W/nf * 0.18u' as='int((nf+2)/2) * W/nf * 0.18u' pd='2*int((nf+1)/2) * (W/nf + 0.18u)' ps='2*int((nf+2)/2) * (W/nf + 0.18u)' nrd='0.18u / W' nrs='0.18u / W' sa=0 sb=0 sd=0
VO_m304 m304o Vmem 0
XR_m305 m305r m305r Vdd Vdd pfet_03v3 L=0.452u W=0.409u nf=1 ad='int((nf+1)/2) * W/nf * 0.18u' as='int((nf+2)/2) * W/nf * 0.18u' pd='2*int((nf+1)/2) * (W/nf + 0.18u)' ps='2*int((nf+2)/2) * (W/nf + 0.18u)' nrd='0.18u / W' nrs='0.18u / W' sa=0 sb=0 sd=0
VR_m305 nref m305r 0
XO_m305 m305o m305r Vdd Vdd pfet_03v3 L=3.707u W=0.25u nf=1 ad='int((nf+1)/2) * W/nf * 0.18u' as='int((nf+2)/2) * W/nf * 0.18u' pd='2*int((nf+1)/2) * (W/nf + 0.18u)' ps='2*int((nf+2)/2) * (W/nf + 0.18u)' nrd='0.18u / W' nrs='0.18u / W' sa=0 sb=0 sd=0
VO_m305 m305o Vmem 0
XR_m306 m306r m306r Vdd Vdd pfet_03v3 L=0.544u W=1.704u nf=1 ad='int((nf+1)/2) * W/nf * 0.18u' as='int((nf+2)/2) * W/nf * 0.18u' pd='2*int((nf+1)/2) * (W/nf + 0.18u)' ps='2*int((nf+2)/2) * (W/nf + 0.18u)' nrd='0.18u / W' nrs='0.18u / W' sa=0 sb=0 sd=0
VR_m306 nref m306r 0
XO_m306 m306o m306r Vdd Vdd pfet_03v3 L=3.169u W=1.588u nf=1 ad='int((nf+1)/2) * W/nf * 0.18u' as='int((nf+2)/2) * W/nf * 0.18u' pd='2*int((nf+1)/2) * (W/nf + 0.18u)' ps='2*int((nf+2)/2) * (W/nf + 0.18u)' nrd='0.18u / W' nrs='0.18u / W' sa=0 sb=0 sd=0
VO_m306 m306o Vmem 0
XR_m307 m307r m307r Vdd Vdd pfet_03v3 L=0.524u W=0.852u nf=1 ad='int((nf+1)/2) * W/nf * 0.18u' as='int((nf+2)/2) * W/nf * 0.18u' pd='2*int((nf+1)/2) * (W/nf + 0.18u)' ps='2*int((nf+2)/2) * (W/nf + 0.18u)' nrd='0.18u / W' nrs='0.18u / W' sa=0 sb=0 sd=0
VR_m307 nref m307r 0
XO_m307 m307o m307r Vdd Vdd pfet_03v3 L=0.563u W=3.626u nf=1 ad='int((nf+1)/2) * W/nf * 0.18u' as='int((nf+2)/2) * W/nf * 0.18u' pd='2*int((nf+1)/2) * (W/nf + 0.18u)' ps='2*int((nf+2)/2) * (W/nf + 0.18u)' nrd='0.18u / W' nrs='0.18u / W' sa=0 sb=0 sd=0
VO_m307 m307o Vmem 0
XR_m308 m308r m308r Vdd Vdd pfet_03v3 L=3.026u W=0.361u nf=1 ad='int((nf+1)/2) * W/nf * 0.18u' as='int((nf+2)/2) * W/nf * 0.18u' pd='2*int((nf+1)/2) * (W/nf + 0.18u)' ps='2*int((nf+2)/2) * (W/nf + 0.18u)' nrd='0.18u / W' nrs='0.18u / W' sa=0 sb=0 sd=0
VR_m308 nref m308r 0
XO_m308 m308o m308r Vdd Vdd pfet_03v3 L=0.385u W=2.482u nf=1 ad='int((nf+1)/2) * W/nf * 0.18u' as='int((nf+2)/2) * W/nf * 0.18u' pd='2*int((nf+1)/2) * (W/nf + 0.18u)' ps='2*int((nf+2)/2) * (W/nf + 0.18u)' nrd='0.18u / W' nrs='0.18u / W' sa=0 sb=0 sd=0
VO_m308 m308o Vmem 0
XR_m309 m309r m309r Vdd Vdd pfet_03v3 L=3.227u W=2.416u nf=1 ad='int((nf+1)/2) * W/nf * 0.18u' as='int((nf+2)/2) * W/nf * 0.18u' pd='2*int((nf+1)/2) * (W/nf + 0.18u)' ps='2*int((nf+2)/2) * (W/nf + 0.18u)' nrd='0.18u / W' nrs='0.18u / W' sa=0 sb=0 sd=0
VR_m309 nref m309r 0
XO_m309 m309o m309r Vdd Vdd pfet_03v3 L=0.285u W=0.281u nf=1 ad='int((nf+1)/2) * W/nf * 0.18u' as='int((nf+2)/2) * W/nf * 0.18u' pd='2*int((nf+1)/2) * (W/nf + 0.18u)' ps='2*int((nf+2)/2) * (W/nf + 0.18u)' nrd='0.18u / W' nrs='0.18u / W' sa=0 sb=0 sd=0
VO_m309 m309o Vmem 0
XR_m310 m310r m310r Vdd Vdd pfet_03v3 L=3.425u W=0.516u nf=1 ad='int((nf+1)/2) * W/nf * 0.18u' as='int((nf+2)/2) * W/nf * 0.18u' pd='2*int((nf+1)/2) * (W/nf + 0.18u)' ps='2*int((nf+2)/2) * (W/nf + 0.18u)' nrd='0.18u / W' nrs='0.18u / W' sa=0 sb=0 sd=0
VR_m310 nref m310r 0
XO_m310 m310o m310r Vdd Vdd pfet_03v3 L=2.272u W=3.179u nf=1 ad='int((nf+1)/2) * W/nf * 0.18u' as='int((nf+2)/2) * W/nf * 0.18u' pd='2*int((nf+1)/2) * (W/nf + 0.18u)' ps='2*int((nf+2)/2) * (W/nf + 0.18u)' nrd='0.18u / W' nrs='0.18u / W' sa=0 sb=0 sd=0
VO_m310 m310o Vmem 0
XR_m311 m311r m311r Vdd Vdd pfet_03v3 L=3.573u W=0.286u nf=1 ad='int((nf+1)/2) * W/nf * 0.18u' as='int((nf+2)/2) * W/nf * 0.18u' pd='2*int((nf+1)/2) * (W/nf + 0.18u)' ps='2*int((nf+2)/2) * (W/nf + 0.18u)' nrd='0.18u / W' nrs='0.18u / W' sa=0 sb=0 sd=0
VR_m311 nref m311r 0
XO_m311 m311o m311r Vdd Vdd pfet_03v3 L=0.524u W=1.132u nf=1 ad='int((nf+1)/2) * W/nf * 0.18u' as='int((nf+2)/2) * W/nf * 0.18u' pd='2*int((nf+1)/2) * (W/nf + 0.18u)' ps='2*int((nf+2)/2) * (W/nf + 0.18u)' nrd='0.18u / W' nrs='0.18u / W' sa=0 sb=0 sd=0
VO_m311 m311o Vmem 0
XR_m312 m312r m312r Vdd Vdd pfet_03v3 L=0.431u W=0.253u nf=1 ad='int((nf+1)/2) * W/nf * 0.18u' as='int((nf+2)/2) * W/nf * 0.18u' pd='2*int((nf+1)/2) * (W/nf + 0.18u)' ps='2*int((nf+2)/2) * (W/nf + 0.18u)' nrd='0.18u / W' nrs='0.18u / W' sa=0 sb=0 sd=0
VR_m312 nref m312r 0
XO_m312 m312o m312r Vdd Vdd pfet_03v3 L=1.036u W=0.32u nf=1 ad='int((nf+1)/2) * W/nf * 0.18u' as='int((nf+2)/2) * W/nf * 0.18u' pd='2*int((nf+1)/2) * (W/nf + 0.18u)' ps='2*int((nf+2)/2) * (W/nf + 0.18u)' nrd='0.18u / W' nrs='0.18u / W' sa=0 sb=0 sd=0
VO_m312 m312o Vmem 0
XR_m313 m313r m313r Vdd Vdd pfet_03v3 L=0.343u W=0.353u nf=1 ad='int((nf+1)/2) * W/nf * 0.18u' as='int((nf+2)/2) * W/nf * 0.18u' pd='2*int((nf+1)/2) * (W/nf + 0.18u)' ps='2*int((nf+2)/2) * (W/nf + 0.18u)' nrd='0.18u / W' nrs='0.18u / W' sa=0 sb=0 sd=0
VR_m313 nref m313r 0
XO_m313 m313o m313r Vdd Vdd pfet_03v3 L=0.382u W=2.281u nf=1 ad='int((nf+1)/2) * W/nf * 0.18u' as='int((nf+2)/2) * W/nf * 0.18u' pd='2*int((nf+1)/2) * (W/nf + 0.18u)' ps='2*int((nf+2)/2) * (W/nf + 0.18u)' nrd='0.18u / W' nrs='0.18u / W' sa=0 sb=0 sd=0
VO_m313 m313o Vmem 0
XR_m314 m314r m314r Vdd Vdd pfet_03v3 L=2.966u W=1.592u nf=1 ad='int((nf+1)/2) * W/nf * 0.18u' as='int((nf+2)/2) * W/nf * 0.18u' pd='2*int((nf+1)/2) * (W/nf + 0.18u)' ps='2*int((nf+2)/2) * (W/nf + 0.18u)' nrd='0.18u / W' nrs='0.18u / W' sa=0 sb=0 sd=0
VR_m314 nref m314r 0
XO_m314 m314o m314r Vdd Vdd pfet_03v3 L=2.731u W=2.496u nf=1 ad='int((nf+1)/2) * W/nf * 0.18u' as='int((nf+2)/2) * W/nf * 0.18u' pd='2*int((nf+1)/2) * (W/nf + 0.18u)' ps='2*int((nf+2)/2) * (W/nf + 0.18u)' nrd='0.18u / W' nrs='0.18u / W' sa=0 sb=0 sd=0
VO_m314 m314o Vmem 0
XR_m315 m315r m315r Vdd Vdd pfet_03v3 L=1.784u W=2.974u nf=1 ad='int((nf+1)/2) * W/nf * 0.18u' as='int((nf+2)/2) * W/nf * 0.18u' pd='2*int((nf+1)/2) * (W/nf + 0.18u)' ps='2*int((nf+2)/2) * (W/nf + 0.18u)' nrd='0.18u / W' nrs='0.18u / W' sa=0 sb=0 sd=0
VR_m315 nref m315r 0
XO_m315 m315o m315r Vdd Vdd pfet_03v3 L=7.189u W=2.028u nf=1 ad='int((nf+1)/2) * W/nf * 0.18u' as='int((nf+2)/2) * W/nf * 0.18u' pd='2*int((nf+1)/2) * (W/nf + 0.18u)' ps='2*int((nf+2)/2) * (W/nf + 0.18u)' nrd='0.18u / W' nrs='0.18u / W' sa=0 sb=0 sd=0
VO_m315 m315o Vmem 0
XR_m316 m316r m316r Vdd Vdd pfet_03v3 L=0.371u W=3.156u nf=1 ad='int((nf+1)/2) * W/nf * 0.18u' as='int((nf+2)/2) * W/nf * 0.18u' pd='2*int((nf+1)/2) * (W/nf + 0.18u)' ps='2*int((nf+2)/2) * (W/nf + 0.18u)' nrd='0.18u / W' nrs='0.18u / W' sa=0 sb=0 sd=0
VR_m316 nref m316r 0
XO_m316 m316o m316r Vdd Vdd pfet_03v3 L=0.398u W=2.606u nf=1 ad='int((nf+1)/2) * W/nf * 0.18u' as='int((nf+2)/2) * W/nf * 0.18u' pd='2*int((nf+1)/2) * (W/nf + 0.18u)' ps='2*int((nf+2)/2) * (W/nf + 0.18u)' nrd='0.18u / W' nrs='0.18u / W' sa=0 sb=0 sd=0
VO_m316 m316o Vmem 0
XR_m317 m317r m317r Vdd Vdd pfet_03v3 L=2.181u W=1.131u nf=1 ad='int((nf+1)/2) * W/nf * 0.18u' as='int((nf+2)/2) * W/nf * 0.18u' pd='2*int((nf+1)/2) * (W/nf + 0.18u)' ps='2*int((nf+2)/2) * (W/nf + 0.18u)' nrd='0.18u / W' nrs='0.18u / W' sa=0 sb=0 sd=0
VR_m317 nref m317r 0
XO_m317 m317o m317r Vdd Vdd pfet_03v3 L=1.309u W=0.497u nf=1 ad='int((nf+1)/2) * W/nf * 0.18u' as='int((nf+2)/2) * W/nf * 0.18u' pd='2*int((nf+1)/2) * (W/nf + 0.18u)' ps='2*int((nf+2)/2) * (W/nf + 0.18u)' nrd='0.18u / W' nrs='0.18u / W' sa=0 sb=0 sd=0
VO_m317 m317o Vmem 0
XR_m318 m318r m318r Vdd Vdd pfet_03v3 L=0.498u W=0.575u nf=1 ad='int((nf+1)/2) * W/nf * 0.18u' as='int((nf+2)/2) * W/nf * 0.18u' pd='2*int((nf+1)/2) * (W/nf + 0.18u)' ps='2*int((nf+2)/2) * (W/nf + 0.18u)' nrd='0.18u / W' nrs='0.18u / W' sa=0 sb=0 sd=0
VR_m318 nref m318r 0
XO_m318 m318o m318r Vdd Vdd pfet_03v3 L=3.224u W=2.299u nf=1 ad='int((nf+1)/2) * W/nf * 0.18u' as='int((nf+2)/2) * W/nf * 0.18u' pd='2*int((nf+1)/2) * (W/nf + 0.18u)' ps='2*int((nf+2)/2) * (W/nf + 0.18u)' nrd='0.18u / W' nrs='0.18u / W' sa=0 sb=0 sd=0
VO_m318 m318o Vmem 0
XR_m319 m319r m319r Vdd Vdd pfet_03v3 L=0.731u W=2.26u nf=1 ad='int((nf+1)/2) * W/nf * 0.18u' as='int((nf+2)/2) * W/nf * 0.18u' pd='2*int((nf+1)/2) * (W/nf + 0.18u)' ps='2*int((nf+2)/2) * (W/nf + 0.18u)' nrd='0.18u / W' nrs='0.18u / W' sa=0 sb=0 sd=0
VR_m319 nref m319r 0
XO_m319 m319o m319r Vdd Vdd pfet_03v3 L=0.808u W=2.682u nf=1 ad='int((nf+1)/2) * W/nf * 0.18u' as='int((nf+2)/2) * W/nf * 0.18u' pd='2*int((nf+1)/2) * (W/nf + 0.18u)' ps='2*int((nf+2)/2) * (W/nf + 0.18u)' nrd='0.18u / W' nrs='0.18u / W' sa=0 sb=0 sd=0
VO_m319 m319o Vmem 0
XR_m320 m320r m320r Vdd Vdd pfet_03v3 L=1.01u W=0.511u nf=1 ad='int((nf+1)/2) * W/nf * 0.18u' as='int((nf+2)/2) * W/nf * 0.18u' pd='2*int((nf+1)/2) * (W/nf + 0.18u)' ps='2*int((nf+2)/2) * (W/nf + 0.18u)' nrd='0.18u / W' nrs='0.18u / W' sa=0 sb=0 sd=0
VR_m320 nref m320r 0
XO_m320 m320o m320r Vdd Vdd pfet_03v3 L=2.165u W=2.829u nf=1 ad='int((nf+1)/2) * W/nf * 0.18u' as='int((nf+2)/2) * W/nf * 0.18u' pd='2*int((nf+1)/2) * (W/nf + 0.18u)' ps='2*int((nf+2)/2) * (W/nf + 0.18u)' nrd='0.18u / W' nrs='0.18u / W' sa=0 sb=0 sd=0
VO_m320 m320o Vmem 0
XR_m321 m321r m321r Vdd Vdd pfet_03v3 L=2.9u W=2.348u nf=1 ad='int((nf+1)/2) * W/nf * 0.18u' as='int((nf+2)/2) * W/nf * 0.18u' pd='2*int((nf+1)/2) * (W/nf + 0.18u)' ps='2*int((nf+2)/2) * (W/nf + 0.18u)' nrd='0.18u / W' nrs='0.18u / W' sa=0 sb=0 sd=0
VR_m321 nref m321r 0
XO_m321 m321o m321r Vdd Vdd pfet_03v3 L=2.935u W=0.956u nf=1 ad='int((nf+1)/2) * W/nf * 0.18u' as='int((nf+2)/2) * W/nf * 0.18u' pd='2*int((nf+1)/2) * (W/nf + 0.18u)' ps='2*int((nf+2)/2) * (W/nf + 0.18u)' nrd='0.18u / W' nrs='0.18u / W' sa=0 sb=0 sd=0
VO_m321 m321o Vmem 0
XR_m322 m322r m322r Vdd Vdd pfet_03v3 L=0.545u W=0.273u nf=1 ad='int((nf+1)/2) * W/nf * 0.18u' as='int((nf+2)/2) * W/nf * 0.18u' pd='2*int((nf+1)/2) * (W/nf + 0.18u)' ps='2*int((nf+2)/2) * (W/nf + 0.18u)' nrd='0.18u / W' nrs='0.18u / W' sa=0 sb=0 sd=0
VR_m322 nref m322r 0
XO_m322 m322o m322r Vdd Vdd pfet_03v3 L=1.675u W=1.512u nf=1 ad='int((nf+1)/2) * W/nf * 0.18u' as='int((nf+2)/2) * W/nf * 0.18u' pd='2*int((nf+1)/2) * (W/nf + 0.18u)' ps='2*int((nf+2)/2) * (W/nf + 0.18u)' nrd='0.18u / W' nrs='0.18u / W' sa=0 sb=0 sd=0
VO_m322 m322o Vmem 0
XR_m323 m323r m323r Vdd Vdd pfet_03v3 L=1.328u W=1.054u nf=1 ad='int((nf+1)/2) * W/nf * 0.18u' as='int((nf+2)/2) * W/nf * 0.18u' pd='2*int((nf+1)/2) * (W/nf + 0.18u)' ps='2*int((nf+2)/2) * (W/nf + 0.18u)' nrd='0.18u / W' nrs='0.18u / W' sa=0 sb=0 sd=0
VR_m323 nref m323r 0
XO_m323 m323o m323r Vdd Vdd pfet_03v3 L=0.374u W=0.271u nf=1 ad='int((nf+1)/2) * W/nf * 0.18u' as='int((nf+2)/2) * W/nf * 0.18u' pd='2*int((nf+1)/2) * (W/nf + 0.18u)' ps='2*int((nf+2)/2) * (W/nf + 0.18u)' nrd='0.18u / W' nrs='0.18u / W' sa=0 sb=0 sd=0
VO_m323 m323o Vmem 0
XR_m324 m324r m324r Vdd Vdd pfet_03v3 L=0.298u W=2.461u nf=1 ad='int((nf+1)/2) * W/nf * 0.18u' as='int((nf+2)/2) * W/nf * 0.18u' pd='2*int((nf+1)/2) * (W/nf + 0.18u)' ps='2*int((nf+2)/2) * (W/nf + 0.18u)' nrd='0.18u / W' nrs='0.18u / W' sa=0 sb=0 sd=0
VR_m324 nref m324r 0
XO_m324 m324o m324r Vdd Vdd pfet_03v3 L=0.958u W=0.269u nf=1 ad='int((nf+1)/2) * W/nf * 0.18u' as='int((nf+2)/2) * W/nf * 0.18u' pd='2*int((nf+1)/2) * (W/nf + 0.18u)' ps='2*int((nf+2)/2) * (W/nf + 0.18u)' nrd='0.18u / W' nrs='0.18u / W' sa=0 sb=0 sd=0
VO_m324 m324o Vmem 0
XR_m325 m325r m325r Vdd Vdd pfet_03v3 L=1.931u W=1.217u nf=1 ad='int((nf+1)/2) * W/nf * 0.18u' as='int((nf+2)/2) * W/nf * 0.18u' pd='2*int((nf+1)/2) * (W/nf + 0.18u)' ps='2*int((nf+2)/2) * (W/nf + 0.18u)' nrd='0.18u / W' nrs='0.18u / W' sa=0 sb=0 sd=0
VR_m325 nref m325r 0
XO_m325 m325o m325r Vdd Vdd pfet_03v3 L=3.549u W=2.406u nf=1 ad='int((nf+1)/2) * W/nf * 0.18u' as='int((nf+2)/2) * W/nf * 0.18u' pd='2*int((nf+1)/2) * (W/nf + 0.18u)' ps='2*int((nf+2)/2) * (W/nf + 0.18u)' nrd='0.18u / W' nrs='0.18u / W' sa=0 sb=0 sd=0
VO_m325 m325o Vmem 0
XR_m326 m326r m326r Vdd Vdd pfet_03v3 L=0.592u W=3.427u nf=1 ad='int((nf+1)/2) * W/nf * 0.18u' as='int((nf+2)/2) * W/nf * 0.18u' pd='2*int((nf+1)/2) * (W/nf + 0.18u)' ps='2*int((nf+2)/2) * (W/nf + 0.18u)' nrd='0.18u / W' nrs='0.18u / W' sa=0 sb=0 sd=0
VR_m326 nref m326r 0
XO_m326 m326o m326r Vdd Vdd pfet_03v3 L=1.242u W=1.646u nf=1 ad='int((nf+1)/2) * W/nf * 0.18u' as='int((nf+2)/2) * W/nf * 0.18u' pd='2*int((nf+1)/2) * (W/nf + 0.18u)' ps='2*int((nf+2)/2) * (W/nf + 0.18u)' nrd='0.18u / W' nrs='0.18u / W' sa=0 sb=0 sd=0
VO_m326 m326o Vmem 0
XR_m327 m327r m327r Vdd Vdd pfet_03v3 L=0.364u W=0.226u nf=1 ad='int((nf+1)/2) * W/nf * 0.18u' as='int((nf+2)/2) * W/nf * 0.18u' pd='2*int((nf+1)/2) * (W/nf + 0.18u)' ps='2*int((nf+2)/2) * (W/nf + 0.18u)' nrd='0.18u / W' nrs='0.18u / W' sa=0 sb=0 sd=0
VR_m327 nref m327r 0
XO_m327 m327o m327r Vdd Vdd pfet_03v3 L=2.675u W=0.706u nf=1 ad='int((nf+1)/2) * W/nf * 0.18u' as='int((nf+2)/2) * W/nf * 0.18u' pd='2*int((nf+1)/2) * (W/nf + 0.18u)' ps='2*int((nf+2)/2) * (W/nf + 0.18u)' nrd='0.18u / W' nrs='0.18u / W' sa=0 sb=0 sd=0
VO_m327 m327o Vmem 0
XR_m328 m328r m328r Vdd Vdd pfet_03v3 L=2.679u W=1.62u nf=1 ad='int((nf+1)/2) * W/nf * 0.18u' as='int((nf+2)/2) * W/nf * 0.18u' pd='2*int((nf+1)/2) * (W/nf + 0.18u)' ps='2*int((nf+2)/2) * (W/nf + 0.18u)' nrd='0.18u / W' nrs='0.18u / W' sa=0 sb=0 sd=0
VR_m328 nref m328r 0
XO_m328 m328o m328r Vdd Vdd pfet_03v3 L=1.541u W=3.1u nf=1 ad='int((nf+1)/2) * W/nf * 0.18u' as='int((nf+2)/2) * W/nf * 0.18u' pd='2*int((nf+1)/2) * (W/nf + 0.18u)' ps='2*int((nf+2)/2) * (W/nf + 0.18u)' nrd='0.18u / W' nrs='0.18u / W' sa=0 sb=0 sd=0
VO_m328 m328o Vmem 0
XR_m329 m329r m329r Vdd Vdd pfet_03v3 L=1.426u W=1.347u nf=1 ad='int((nf+1)/2) * W/nf * 0.18u' as='int((nf+2)/2) * W/nf * 0.18u' pd='2*int((nf+1)/2) * (W/nf + 0.18u)' ps='2*int((nf+2)/2) * (W/nf + 0.18u)' nrd='0.18u / W' nrs='0.18u / W' sa=0 sb=0 sd=0
VR_m329 nref m329r 0
XO_m329 m329o m329r Vdd Vdd pfet_03v3 L=2.062u W=0.799u nf=1 ad='int((nf+1)/2) * W/nf * 0.18u' as='int((nf+2)/2) * W/nf * 0.18u' pd='2*int((nf+1)/2) * (W/nf + 0.18u)' ps='2*int((nf+2)/2) * (W/nf + 0.18u)' nrd='0.18u / W' nrs='0.18u / W' sa=0 sb=0 sd=0
VO_m329 m329o Vmem 0
XR_m330 m330r m330r Vdd Vdd pfet_03v3 L=1.37u W=3.014u nf=1 ad='int((nf+1)/2) * W/nf * 0.18u' as='int((nf+2)/2) * W/nf * 0.18u' pd='2*int((nf+1)/2) * (W/nf + 0.18u)' ps='2*int((nf+2)/2) * (W/nf + 0.18u)' nrd='0.18u / W' nrs='0.18u / W' sa=0 sb=0 sd=0
VR_m330 nref m330r 0
XO_m330 m330o m330r Vdd Vdd pfet_03v3 L=2.902u W=1.67u nf=1 ad='int((nf+1)/2) * W/nf * 0.18u' as='int((nf+2)/2) * W/nf * 0.18u' pd='2*int((nf+1)/2) * (W/nf + 0.18u)' ps='2*int((nf+2)/2) * (W/nf + 0.18u)' nrd='0.18u / W' nrs='0.18u / W' sa=0 sb=0 sd=0
VO_m330 m330o Vmem 0
XR_m331 m331r m331r Vdd Vdd pfet_03v3 L=0.895u W=0.607u nf=1 ad='int((nf+1)/2) * W/nf * 0.18u' as='int((nf+2)/2) * W/nf * 0.18u' pd='2*int((nf+1)/2) * (W/nf + 0.18u)' ps='2*int((nf+2)/2) * (W/nf + 0.18u)' nrd='0.18u / W' nrs='0.18u / W' sa=0 sb=0 sd=0
VR_m331 nref m331r 0
XO_m331 m331o m331r Vdd Vdd pfet_03v3 L=2.236u W=0.369u nf=1 ad='int((nf+1)/2) * W/nf * 0.18u' as='int((nf+2)/2) * W/nf * 0.18u' pd='2*int((nf+1)/2) * (W/nf + 0.18u)' ps='2*int((nf+2)/2) * (W/nf + 0.18u)' nrd='0.18u / W' nrs='0.18u / W' sa=0 sb=0 sd=0
VO_m331 m331o Vmem 0
XR_m332 m332r m332r Vdd Vdd pfet_03v3 L=0.434u W=0.63u nf=1 ad='int((nf+1)/2) * W/nf * 0.18u' as='int((nf+2)/2) * W/nf * 0.18u' pd='2*int((nf+1)/2) * (W/nf + 0.18u)' ps='2*int((nf+2)/2) * (W/nf + 0.18u)' nrd='0.18u / W' nrs='0.18u / W' sa=0 sb=0 sd=0
VR_m332 nref m332r 0
XO_m332 m332o m332r Vdd Vdd pfet_03v3 L=1.496u W=0.289u nf=1 ad='int((nf+1)/2) * W/nf * 0.18u' as='int((nf+2)/2) * W/nf * 0.18u' pd='2*int((nf+1)/2) * (W/nf + 0.18u)' ps='2*int((nf+2)/2) * (W/nf + 0.18u)' nrd='0.18u / W' nrs='0.18u / W' sa=0 sb=0 sd=0
VO_m332 m332o Vmem 0
XR_m333 m333r m333r Vdd Vdd pfet_03v3 L=3.132u W=2.357u nf=1 ad='int((nf+1)/2) * W/nf * 0.18u' as='int((nf+2)/2) * W/nf * 0.18u' pd='2*int((nf+1)/2) * (W/nf + 0.18u)' ps='2*int((nf+2)/2) * (W/nf + 0.18u)' nrd='0.18u / W' nrs='0.18u / W' sa=0 sb=0 sd=0
VR_m333 nref m333r 0
XO_m333 m333o m333r Vdd Vdd pfet_03v3 L=0.287u W=2.877u nf=1 ad='int((nf+1)/2) * W/nf * 0.18u' as='int((nf+2)/2) * W/nf * 0.18u' pd='2*int((nf+1)/2) * (W/nf + 0.18u)' ps='2*int((nf+2)/2) * (W/nf + 0.18u)' nrd='0.18u / W' nrs='0.18u / W' sa=0 sb=0 sd=0
VO_m333 m333o Vmem 0
XR_m334 m334r m334r Vdd Vdd pfet_03v3 L=0.31u W=0.432u nf=1 ad='int((nf+1)/2) * W/nf * 0.18u' as='int((nf+2)/2) * W/nf * 0.18u' pd='2*int((nf+1)/2) * (W/nf + 0.18u)' ps='2*int((nf+2)/2) * (W/nf + 0.18u)' nrd='0.18u / W' nrs='0.18u / W' sa=0 sb=0 sd=0
VR_m334 nref m334r 0
XO_m334 m334o m334r Vdd Vdd pfet_03v3 L=1.018u W=0.882u nf=1 ad='int((nf+1)/2) * W/nf * 0.18u' as='int((nf+2)/2) * W/nf * 0.18u' pd='2*int((nf+1)/2) * (W/nf + 0.18u)' ps='2*int((nf+2)/2) * (W/nf + 0.18u)' nrd='0.18u / W' nrs='0.18u / W' sa=0 sb=0 sd=0
VO_m334 m334o Vmem 0
XR_m335 m335r m335r Vdd Vdd pfet_03v3 L=0.309u W=0.732u nf=1 ad='int((nf+1)/2) * W/nf * 0.18u' as='int((nf+2)/2) * W/nf * 0.18u' pd='2*int((nf+1)/2) * (W/nf + 0.18u)' ps='2*int((nf+2)/2) * (W/nf + 0.18u)' nrd='0.18u / W' nrs='0.18u / W' sa=0 sb=0 sd=0
VR_m335 nref m335r 0
XO_m335 m335o m335r Vdd Vdd pfet_03v3 L=0.658u W=1.961u nf=1 ad='int((nf+1)/2) * W/nf * 0.18u' as='int((nf+2)/2) * W/nf * 0.18u' pd='2*int((nf+1)/2) * (W/nf + 0.18u)' ps='2*int((nf+2)/2) * (W/nf + 0.18u)' nrd='0.18u / W' nrs='0.18u / W' sa=0 sb=0 sd=0
VO_m335 m335o Vmem 0
XR_m336 m336r m336r Vdd Vdd pfet_03v3 L=3.028u W=3.12u nf=1 ad='int((nf+1)/2) * W/nf * 0.18u' as='int((nf+2)/2) * W/nf * 0.18u' pd='2*int((nf+1)/2) * (W/nf + 0.18u)' ps='2*int((nf+2)/2) * (W/nf + 0.18u)' nrd='0.18u / W' nrs='0.18u / W' sa=0 sb=0 sd=0
VR_m336 nref m336r 0
XO_m336 m336o m336r Vdd Vdd pfet_03v3 L=0.74u W=2.736u nf=1 ad='int((nf+1)/2) * W/nf * 0.18u' as='int((nf+2)/2) * W/nf * 0.18u' pd='2*int((nf+1)/2) * (W/nf + 0.18u)' ps='2*int((nf+2)/2) * (W/nf + 0.18u)' nrd='0.18u / W' nrs='0.18u / W' sa=0 sb=0 sd=0
VO_m336 m336o Vmem 0
XR_m337 m337r m337r Vdd Vdd pfet_03v3 L=0.615u W=1.1u nf=1 ad='int((nf+1)/2) * W/nf * 0.18u' as='int((nf+2)/2) * W/nf * 0.18u' pd='2*int((nf+1)/2) * (W/nf + 0.18u)' ps='2*int((nf+2)/2) * (W/nf + 0.18u)' nrd='0.18u / W' nrs='0.18u / W' sa=0 sb=0 sd=0
VR_m337 nref m337r 0
XO_m337 m337o m337r Vdd Vdd pfet_03v3 L=3.659u W=0.906u nf=1 ad='int((nf+1)/2) * W/nf * 0.18u' as='int((nf+2)/2) * W/nf * 0.18u' pd='2*int((nf+1)/2) * (W/nf + 0.18u)' ps='2*int((nf+2)/2) * (W/nf + 0.18u)' nrd='0.18u / W' nrs='0.18u / W' sa=0 sb=0 sd=0
VO_m337 m337o Vmem 0
XR_m338 m338r m338r Vdd Vdd pfet_03v3 L=2.934u W=0.829u nf=1 ad='int((nf+1)/2) * W/nf * 0.18u' as='int((nf+2)/2) * W/nf * 0.18u' pd='2*int((nf+1)/2) * (W/nf + 0.18u)' ps='2*int((nf+2)/2) * (W/nf + 0.18u)' nrd='0.18u / W' nrs='0.18u / W' sa=0 sb=0 sd=0
VR_m338 nref m338r 0
XO_m338 m338o m338r Vdd Vdd pfet_03v3 L=0.35u W=2.823u nf=1 ad='int((nf+1)/2) * W/nf * 0.18u' as='int((nf+2)/2) * W/nf * 0.18u' pd='2*int((nf+1)/2) * (W/nf + 0.18u)' ps='2*int((nf+2)/2) * (W/nf + 0.18u)' nrd='0.18u / W' nrs='0.18u / W' sa=0 sb=0 sd=0
VO_m338 m338o Vmem 0
XR_m339 m339r m339r Vdd Vdd pfet_03v3 L=0.949u W=0.575u nf=1 ad='int((nf+1)/2) * W/nf * 0.18u' as='int((nf+2)/2) * W/nf * 0.18u' pd='2*int((nf+1)/2) * (W/nf + 0.18u)' ps='2*int((nf+2)/2) * (W/nf + 0.18u)' nrd='0.18u / W' nrs='0.18u / W' sa=0 sb=0 sd=0
VR_m339 nref m339r 0
XO_m339 m339o m339r Vdd Vdd pfet_03v3 L=0.397u W=2.374u nf=1 ad='int((nf+1)/2) * W/nf * 0.18u' as='int((nf+2)/2) * W/nf * 0.18u' pd='2*int((nf+1)/2) * (W/nf + 0.18u)' ps='2*int((nf+2)/2) * (W/nf + 0.18u)' nrd='0.18u / W' nrs='0.18u / W' sa=0 sb=0 sd=0
VO_m339 m339o Vmem 0
XR_m340 m340r m340r Vdd Vdd pfet_03v3 L=0.41u W=0.397u nf=1 ad='int((nf+1)/2) * W/nf * 0.18u' as='int((nf+2)/2) * W/nf * 0.18u' pd='2*int((nf+1)/2) * (W/nf + 0.18u)' ps='2*int((nf+2)/2) * (W/nf + 0.18u)' nrd='0.18u / W' nrs='0.18u / W' sa=0 sb=0 sd=0
VR_m340 nref m340r 0
XO_m340 m340o m340r Vdd Vdd pfet_03v3 L=1.573u W=3.764u nf=1 ad='int((nf+1)/2) * W/nf * 0.18u' as='int((nf+2)/2) * W/nf * 0.18u' pd='2*int((nf+1)/2) * (W/nf + 0.18u)' ps='2*int((nf+2)/2) * (W/nf + 0.18u)' nrd='0.18u / W' nrs='0.18u / W' sa=0 sb=0 sd=0
VO_m340 m340o Vmem 0
XR_m341 m341r m341r Vdd Vdd pfet_03v3 L=1.396u W=2.163u nf=1 ad='int((nf+1)/2) * W/nf * 0.18u' as='int((nf+2)/2) * W/nf * 0.18u' pd='2*int((nf+1)/2) * (W/nf + 0.18u)' ps='2*int((nf+2)/2) * (W/nf + 0.18u)' nrd='0.18u / W' nrs='0.18u / W' sa=0 sb=0 sd=0
VR_m341 nref m341r 0
XO_m341 m341o m341r Vdd Vdd pfet_03v3 L=4.796u W=2.153u nf=1 ad='int((nf+1)/2) * W/nf * 0.18u' as='int((nf+2)/2) * W/nf * 0.18u' pd='2*int((nf+1)/2) * (W/nf + 0.18u)' ps='2*int((nf+2)/2) * (W/nf + 0.18u)' nrd='0.18u / W' nrs='0.18u / W' sa=0 sb=0 sd=0
VO_m341 m341o Vmem 0
XR_m342 m342r m342r Vdd Vdd pfet_03v3 L=0.334u W=1.937u nf=1 ad='int((nf+1)/2) * W/nf * 0.18u' as='int((nf+2)/2) * W/nf * 0.18u' pd='2*int((nf+1)/2) * (W/nf + 0.18u)' ps='2*int((nf+2)/2) * (W/nf + 0.18u)' nrd='0.18u / W' nrs='0.18u / W' sa=0 sb=0 sd=0
VR_m342 nref m342r 0
XO_m342 m342o m342r Vdd Vdd pfet_03v3 L=3.279u W=2.661u nf=1 ad='int((nf+1)/2) * W/nf * 0.18u' as='int((nf+2)/2) * W/nf * 0.18u' pd='2*int((nf+1)/2) * (W/nf + 0.18u)' ps='2*int((nf+2)/2) * (W/nf + 0.18u)' nrd='0.18u / W' nrs='0.18u / W' sa=0 sb=0 sd=0
VO_m342 m342o Vmem 0
XR_m343 m343r m343r Vdd Vdd pfet_03v3 L=0.295u W=1.74u nf=1 ad='int((nf+1)/2) * W/nf * 0.18u' as='int((nf+2)/2) * W/nf * 0.18u' pd='2*int((nf+1)/2) * (W/nf + 0.18u)' ps='2*int((nf+2)/2) * (W/nf + 0.18u)' nrd='0.18u / W' nrs='0.18u / W' sa=0 sb=0 sd=0
VR_m343 nref m343r 0
XO_m343 m343o m343r Vdd Vdd pfet_03v3 L=1.899u W=2.041u nf=1 ad='int((nf+1)/2) * W/nf * 0.18u' as='int((nf+2)/2) * W/nf * 0.18u' pd='2*int((nf+1)/2) * (W/nf + 0.18u)' ps='2*int((nf+2)/2) * (W/nf + 0.18u)' nrd='0.18u / W' nrs='0.18u / W' sa=0 sb=0 sd=0
VO_m343 m343o Vmem 0
XR_m344 m344r m344r Vdd Vdd pfet_03v3 L=2.951u W=0.268u nf=1 ad='int((nf+1)/2) * W/nf * 0.18u' as='int((nf+2)/2) * W/nf * 0.18u' pd='2*int((nf+1)/2) * (W/nf + 0.18u)' ps='2*int((nf+2)/2) * (W/nf + 0.18u)' nrd='0.18u / W' nrs='0.18u / W' sa=0 sb=0 sd=0
VR_m344 nref m344r 0
XO_m344 m344o m344r Vdd Vdd pfet_03v3 L=2.331u W=0.278u nf=1 ad='int((nf+1)/2) * W/nf * 0.18u' as='int((nf+2)/2) * W/nf * 0.18u' pd='2*int((nf+1)/2) * (W/nf + 0.18u)' ps='2*int((nf+2)/2) * (W/nf + 0.18u)' nrd='0.18u / W' nrs='0.18u / W' sa=0 sb=0 sd=0
VO_m344 m344o Vmem 0
XR_m345 m345r m345r Vdd Vdd pfet_03v3 L=0.382u W=1.939u nf=1 ad='int((nf+1)/2) * W/nf * 0.18u' as='int((nf+2)/2) * W/nf * 0.18u' pd='2*int((nf+1)/2) * (W/nf + 0.18u)' ps='2*int((nf+2)/2) * (W/nf + 0.18u)' nrd='0.18u / W' nrs='0.18u / W' sa=0 sb=0 sd=0
VR_m345 nref m345r 0
XO_m345 m345o m345r Vdd Vdd pfet_03v3 L=1.972u W=2.988u nf=1 ad='int((nf+1)/2) * W/nf * 0.18u' as='int((nf+2)/2) * W/nf * 0.18u' pd='2*int((nf+1)/2) * (W/nf + 0.18u)' ps='2*int((nf+2)/2) * (W/nf + 0.18u)' nrd='0.18u / W' nrs='0.18u / W' sa=0 sb=0 sd=0
VO_m345 m345o Vmem 0
XR_m346 m346r m346r Vdd Vdd pfet_03v3 L=0.368u W=0.248u nf=1 ad='int((nf+1)/2) * W/nf * 0.18u' as='int((nf+2)/2) * W/nf * 0.18u' pd='2*int((nf+1)/2) * (W/nf + 0.18u)' ps='2*int((nf+2)/2) * (W/nf + 0.18u)' nrd='0.18u / W' nrs='0.18u / W' sa=0 sb=0 sd=0
VR_m346 nref m346r 0
XO_m346 m346o m346r Vdd Vdd pfet_03v3 L=1.423u W=3.385u nf=1 ad='int((nf+1)/2) * W/nf * 0.18u' as='int((nf+2)/2) * W/nf * 0.18u' pd='2*int((nf+1)/2) * (W/nf + 0.18u)' ps='2*int((nf+2)/2) * (W/nf + 0.18u)' nrd='0.18u / W' nrs='0.18u / W' sa=0 sb=0 sd=0
VO_m346 m346o Vmem 0
XR_m347 m347r m347r Vdd Vdd pfet_03v3 L=0.403u W=0.592u nf=1 ad='int((nf+1)/2) * W/nf * 0.18u' as='int((nf+2)/2) * W/nf * 0.18u' pd='2*int((nf+1)/2) * (W/nf + 0.18u)' ps='2*int((nf+2)/2) * (W/nf + 0.18u)' nrd='0.18u / W' nrs='0.18u / W' sa=0 sb=0 sd=0
VR_m347 nref m347r 0
XO_m347 m347o m347r Vdd Vdd pfet_03v3 L=0.326u W=0.796u nf=1 ad='int((nf+1)/2) * W/nf * 0.18u' as='int((nf+2)/2) * W/nf * 0.18u' pd='2*int((nf+1)/2) * (W/nf + 0.18u)' ps='2*int((nf+2)/2) * (W/nf + 0.18u)' nrd='0.18u / W' nrs='0.18u / W' sa=0 sb=0 sd=0
VO_m347 m347o Vmem 0
XR_m348 m348r m348r Vdd Vdd pfet_03v3 L=2.269u W=0.313u nf=1 ad='int((nf+1)/2) * W/nf * 0.18u' as='int((nf+2)/2) * W/nf * 0.18u' pd='2*int((nf+1)/2) * (W/nf + 0.18u)' ps='2*int((nf+2)/2) * (W/nf + 0.18u)' nrd='0.18u / W' nrs='0.18u / W' sa=0 sb=0 sd=0
VR_m348 nref m348r 0
XO_m348 m348o m348r Vdd Vdd pfet_03v3 L=0.37u W=3.27u nf=1 ad='int((nf+1)/2) * W/nf * 0.18u' as='int((nf+2)/2) * W/nf * 0.18u' pd='2*int((nf+1)/2) * (W/nf + 0.18u)' ps='2*int((nf+2)/2) * (W/nf + 0.18u)' nrd='0.18u / W' nrs='0.18u / W' sa=0 sb=0 sd=0
VO_m348 m348o Vmem 0
XR_m349 m349r m349r Vdd Vdd pfet_03v3 L=0.422u W=2.679u nf=1 ad='int((nf+1)/2) * W/nf * 0.18u' as='int((nf+2)/2) * W/nf * 0.18u' pd='2*int((nf+1)/2) * (W/nf + 0.18u)' ps='2*int((nf+2)/2) * (W/nf + 0.18u)' nrd='0.18u / W' nrs='0.18u / W' sa=0 sb=0 sd=0
VR_m349 nref m349r 0
XO_m349 m349o m349r Vdd Vdd pfet_03v3 L=1.252u W=0.605u nf=1 ad='int((nf+1)/2) * W/nf * 0.18u' as='int((nf+2)/2) * W/nf * 0.18u' pd='2*int((nf+1)/2) * (W/nf + 0.18u)' ps='2*int((nf+2)/2) * (W/nf + 0.18u)' nrd='0.18u / W' nrs='0.18u / W' sa=0 sb=0 sd=0
VO_m349 m349o Vmem 0
XR_m350 m350r m350r Vdd Vdd pfet_03v3 L=2.954u W=0.47u nf=1 ad='int((nf+1)/2) * W/nf * 0.18u' as='int((nf+2)/2) * W/nf * 0.18u' pd='2*int((nf+1)/2) * (W/nf + 0.18u)' ps='2*int((nf+2)/2) * (W/nf + 0.18u)' nrd='0.18u / W' nrs='0.18u / W' sa=0 sb=0 sd=0
VR_m350 nref m350r 0
XO_m350 m350o m350r Vdd Vdd pfet_03v3 L=1.003u W=2.194u nf=1 ad='int((nf+1)/2) * W/nf * 0.18u' as='int((nf+2)/2) * W/nf * 0.18u' pd='2*int((nf+1)/2) * (W/nf + 0.18u)' ps='2*int((nf+2)/2) * (W/nf + 0.18u)' nrd='0.18u / W' nrs='0.18u / W' sa=0 sb=0 sd=0
VO_m350 m350o Vmem 0
XR_m351 m351r m351r Vdd Vdd pfet_03v3 L=0.689u W=0.378u nf=1 ad='int((nf+1)/2) * W/nf * 0.18u' as='int((nf+2)/2) * W/nf * 0.18u' pd='2*int((nf+1)/2) * (W/nf + 0.18u)' ps='2*int((nf+2)/2) * (W/nf + 0.18u)' nrd='0.18u / W' nrs='0.18u / W' sa=0 sb=0 sd=0
VR_m351 nref m351r 0
XO_m351 m351o m351r Vdd Vdd pfet_03v3 L=1.417u W=0.943u nf=1 ad='int((nf+1)/2) * W/nf * 0.18u' as='int((nf+2)/2) * W/nf * 0.18u' pd='2*int((nf+1)/2) * (W/nf + 0.18u)' ps='2*int((nf+2)/2) * (W/nf + 0.18u)' nrd='0.18u / W' nrs='0.18u / W' sa=0 sb=0 sd=0
VO_m351 m351o Vmem 0
XR_m352 m352r m352r Vdd Vdd pfet_03v3 L=1.402u W=1.282u nf=1 ad='int((nf+1)/2) * W/nf * 0.18u' as='int((nf+2)/2) * W/nf * 0.18u' pd='2*int((nf+1)/2) * (W/nf + 0.18u)' ps='2*int((nf+2)/2) * (W/nf + 0.18u)' nrd='0.18u / W' nrs='0.18u / W' sa=0 sb=0 sd=0
VR_m352 nref m352r 0
XO_m352 m352o m352r Vdd Vdd pfet_03v3 L=1.152u W=1.43u nf=1 ad='int((nf+1)/2) * W/nf * 0.18u' as='int((nf+2)/2) * W/nf * 0.18u' pd='2*int((nf+1)/2) * (W/nf + 0.18u)' ps='2*int((nf+2)/2) * (W/nf + 0.18u)' nrd='0.18u / W' nrs='0.18u / W' sa=0 sb=0 sd=0
VO_m352 m352o Vmem 0
XR_m353 m353r m353r Vdd Vdd pfet_03v3 L=0.455u W=0.648u nf=1 ad='int((nf+1)/2) * W/nf * 0.18u' as='int((nf+2)/2) * W/nf * 0.18u' pd='2*int((nf+1)/2) * (W/nf + 0.18u)' ps='2*int((nf+2)/2) * (W/nf + 0.18u)' nrd='0.18u / W' nrs='0.18u / W' sa=0 sb=0 sd=0
VR_m353 nref m353r 0
XO_m353 m353o m353r Vdd Vdd pfet_03v3 L=0.408u W=1.147u nf=1 ad='int((nf+1)/2) * W/nf * 0.18u' as='int((nf+2)/2) * W/nf * 0.18u' pd='2*int((nf+1)/2) * (W/nf + 0.18u)' ps='2*int((nf+2)/2) * (W/nf + 0.18u)' nrd='0.18u / W' nrs='0.18u / W' sa=0 sb=0 sd=0
VO_m353 m353o Vmem 0
XR_m354 m354r m354r Vdd Vdd pfet_03v3 L=0.832u W=2.75u nf=1 ad='int((nf+1)/2) * W/nf * 0.18u' as='int((nf+2)/2) * W/nf * 0.18u' pd='2*int((nf+1)/2) * (W/nf + 0.18u)' ps='2*int((nf+2)/2) * (W/nf + 0.18u)' nrd='0.18u / W' nrs='0.18u / W' sa=0 sb=0 sd=0
VR_m354 nref m354r 0
XO_m354 m354o m354r Vdd Vdd pfet_03v3 L=1.558u W=1.648u nf=1 ad='int((nf+1)/2) * W/nf * 0.18u' as='int((nf+2)/2) * W/nf * 0.18u' pd='2*int((nf+1)/2) * (W/nf + 0.18u)' ps='2*int((nf+2)/2) * (W/nf + 0.18u)' nrd='0.18u / W' nrs='0.18u / W' sa=0 sb=0 sd=0
VO_m354 m354o Vmem 0
XR_m355 m355r m355r Vdd Vdd pfet_03v3 L=1.806u W=0.875u nf=1 ad='int((nf+1)/2) * W/nf * 0.18u' as='int((nf+2)/2) * W/nf * 0.18u' pd='2*int((nf+1)/2) * (W/nf + 0.18u)' ps='2*int((nf+2)/2) * (W/nf + 0.18u)' nrd='0.18u / W' nrs='0.18u / W' sa=0 sb=0 sd=0
VR_m355 nref m355r 0
XO_m355 m355o m355r Vdd Vdd pfet_03v3 L=0.44u W=0.739u nf=1 ad='int((nf+1)/2) * W/nf * 0.18u' as='int((nf+2)/2) * W/nf * 0.18u' pd='2*int((nf+1)/2) * (W/nf + 0.18u)' ps='2*int((nf+2)/2) * (W/nf + 0.18u)' nrd='0.18u / W' nrs='0.18u / W' sa=0 sb=0 sd=0
VO_m355 m355o Vmem 0
XR_m356 m356r m356r Vdd Vdd pfet_03v3 L=0.295u W=0.444u nf=1 ad='int((nf+1)/2) * W/nf * 0.18u' as='int((nf+2)/2) * W/nf * 0.18u' pd='2*int((nf+1)/2) * (W/nf + 0.18u)' ps='2*int((nf+2)/2) * (W/nf + 0.18u)' nrd='0.18u / W' nrs='0.18u / W' sa=0 sb=0 sd=0
VR_m356 nref m356r 0
XO_m356 m356o m356r Vdd Vdd pfet_03v3 L=1.677u W=0.619u nf=1 ad='int((nf+1)/2) * W/nf * 0.18u' as='int((nf+2)/2) * W/nf * 0.18u' pd='2*int((nf+1)/2) * (W/nf + 0.18u)' ps='2*int((nf+2)/2) * (W/nf + 0.18u)' nrd='0.18u / W' nrs='0.18u / W' sa=0 sb=0 sd=0
VO_m356 m356o Vmem 0
XR_m357 m357r m357r Vdd Vdd pfet_03v3 L=0.855u W=3.679u nf=1 ad='int((nf+1)/2) * W/nf * 0.18u' as='int((nf+2)/2) * W/nf * 0.18u' pd='2*int((nf+1)/2) * (W/nf + 0.18u)' ps='2*int((nf+2)/2) * (W/nf + 0.18u)' nrd='0.18u / W' nrs='0.18u / W' sa=0 sb=0 sd=0
VR_m357 nref m357r 0
XO_m357 m357o m357r Vdd Vdd pfet_03v3 L=1.501u W=0.867u nf=1 ad='int((nf+1)/2) * W/nf * 0.18u' as='int((nf+2)/2) * W/nf * 0.18u' pd='2*int((nf+1)/2) * (W/nf + 0.18u)' ps='2*int((nf+2)/2) * (W/nf + 0.18u)' nrd='0.18u / W' nrs='0.18u / W' sa=0 sb=0 sd=0
VO_m357 m357o Vmem 0
XR_m358 m358r m358r Vdd Vdd pfet_03v3 L=3.059u W=0.333u nf=1 ad='int((nf+1)/2) * W/nf * 0.18u' as='int((nf+2)/2) * W/nf * 0.18u' pd='2*int((nf+1)/2) * (W/nf + 0.18u)' ps='2*int((nf+2)/2) * (W/nf + 0.18u)' nrd='0.18u / W' nrs='0.18u / W' sa=0 sb=0 sd=0
VR_m358 nref m358r 0
XO_m358 m358o m358r Vdd Vdd pfet_03v3 L=0.283u W=0.472u nf=1 ad='int((nf+1)/2) * W/nf * 0.18u' as='int((nf+2)/2) * W/nf * 0.18u' pd='2*int((nf+1)/2) * (W/nf + 0.18u)' ps='2*int((nf+2)/2) * (W/nf + 0.18u)' nrd='0.18u / W' nrs='0.18u / W' sa=0 sb=0 sd=0
VO_m358 m358o Vmem 0
XR_m359 m359r m359r Vdd Vdd pfet_03v3 L=0.476u W=1.956u nf=1 ad='int((nf+1)/2) * W/nf * 0.18u' as='int((nf+2)/2) * W/nf * 0.18u' pd='2*int((nf+1)/2) * (W/nf + 0.18u)' ps='2*int((nf+2)/2) * (W/nf + 0.18u)' nrd='0.18u / W' nrs='0.18u / W' sa=0 sb=0 sd=0
VR_m359 nref m359r 0
XO_m359 m359o m359r Vdd Vdd pfet_03v3 L=0.286u W=0.723u nf=1 ad='int((nf+1)/2) * W/nf * 0.18u' as='int((nf+2)/2) * W/nf * 0.18u' pd='2*int((nf+1)/2) * (W/nf + 0.18u)' ps='2*int((nf+2)/2) * (W/nf + 0.18u)' nrd='0.18u / W' nrs='0.18u / W' sa=0 sb=0 sd=0
VO_m359 m359o Vmem 0
XR_m360 m360r m360r Vdd Vdd pfet_03v3 L=1.438u W=1.666u nf=1 ad='int((nf+1)/2) * W/nf * 0.18u' as='int((nf+2)/2) * W/nf * 0.18u' pd='2*int((nf+1)/2) * (W/nf + 0.18u)' ps='2*int((nf+2)/2) * (W/nf + 0.18u)' nrd='0.18u / W' nrs='0.18u / W' sa=0 sb=0 sd=0
VR_m360 nref m360r 0
XO_m360 m360o m360r Vdd Vdd pfet_03v3 L=1.859u W=3.428u nf=1 ad='int((nf+1)/2) * W/nf * 0.18u' as='int((nf+2)/2) * W/nf * 0.18u' pd='2*int((nf+1)/2) * (W/nf + 0.18u)' ps='2*int((nf+2)/2) * (W/nf + 0.18u)' nrd='0.18u / W' nrs='0.18u / W' sa=0 sb=0 sd=0
VO_m360 m360o Vmem 0
XR_m361 m361r m361r Vdd Vdd pfet_03v3 L=2.213u W=0.859u nf=1 ad='int((nf+1)/2) * W/nf * 0.18u' as='int((nf+2)/2) * W/nf * 0.18u' pd='2*int((nf+1)/2) * (W/nf + 0.18u)' ps='2*int((nf+2)/2) * (W/nf + 0.18u)' nrd='0.18u / W' nrs='0.18u / W' sa=0 sb=0 sd=0
VR_m361 nref m361r 0
XO_m361 m361o m361r Vdd Vdd pfet_03v3 L=0.335u W=0.278u nf=1 ad='int((nf+1)/2) * W/nf * 0.18u' as='int((nf+2)/2) * W/nf * 0.18u' pd='2*int((nf+1)/2) * (W/nf + 0.18u)' ps='2*int((nf+2)/2) * (W/nf + 0.18u)' nrd='0.18u / W' nrs='0.18u / W' sa=0 sb=0 sd=0
VO_m361 m361o Vmem 0
XR_m362 m362r m362r Vdd Vdd pfet_03v3 L=1.276u W=1.277u nf=1 ad='int((nf+1)/2) * W/nf * 0.18u' as='int((nf+2)/2) * W/nf * 0.18u' pd='2*int((nf+1)/2) * (W/nf + 0.18u)' ps='2*int((nf+2)/2) * (W/nf + 0.18u)' nrd='0.18u / W' nrs='0.18u / W' sa=0 sb=0 sd=0
VR_m362 nref m362r 0
XO_m362 m362o m362r Vdd Vdd pfet_03v3 L=2.178u W=0.462u nf=1 ad='int((nf+1)/2) * W/nf * 0.18u' as='int((nf+2)/2) * W/nf * 0.18u' pd='2*int((nf+1)/2) * (W/nf + 0.18u)' ps='2*int((nf+2)/2) * (W/nf + 0.18u)' nrd='0.18u / W' nrs='0.18u / W' sa=0 sb=0 sd=0
VO_m362 m362o Vmem 0
XR_m363 m363r m363r Vdd Vdd pfet_03v3 L=0.546u W=0.585u nf=1 ad='int((nf+1)/2) * W/nf * 0.18u' as='int((nf+2)/2) * W/nf * 0.18u' pd='2*int((nf+1)/2) * (W/nf + 0.18u)' ps='2*int((nf+2)/2) * (W/nf + 0.18u)' nrd='0.18u / W' nrs='0.18u / W' sa=0 sb=0 sd=0
VR_m363 nref m363r 0
XO_m363 m363o m363r Vdd Vdd pfet_03v3 L=7.268u W=0.25u nf=1 ad='int((nf+1)/2) * W/nf * 0.18u' as='int((nf+2)/2) * W/nf * 0.18u' pd='2*int((nf+1)/2) * (W/nf + 0.18u)' ps='2*int((nf+2)/2) * (W/nf + 0.18u)' nrd='0.18u / W' nrs='0.18u / W' sa=0 sb=0 sd=0
VO_m363 m363o Vmem 0
XR_m364 m364r m364r Vdd Vdd pfet_03v3 L=0.285u W=0.38u nf=1 ad='int((nf+1)/2) * W/nf * 0.18u' as='int((nf+2)/2) * W/nf * 0.18u' pd='2*int((nf+1)/2) * (W/nf + 0.18u)' ps='2*int((nf+2)/2) * (W/nf + 0.18u)' nrd='0.18u / W' nrs='0.18u / W' sa=0 sb=0 sd=0
VR_m364 nref m364r 0
XO_m364 m364o m364r Vdd Vdd pfet_03v3 L=4.976u W=1.264u nf=1 ad='int((nf+1)/2) * W/nf * 0.18u' as='int((nf+2)/2) * W/nf * 0.18u' pd='2*int((nf+1)/2) * (W/nf + 0.18u)' ps='2*int((nf+2)/2) * (W/nf + 0.18u)' nrd='0.18u / W' nrs='0.18u / W' sa=0 sb=0 sd=0
VO_m364 m364o Vmem 0
XR_m365 m365r m365r Vdd Vdd pfet_03v3 L=1.059u W=1.391u nf=1 ad='int((nf+1)/2) * W/nf * 0.18u' as='int((nf+2)/2) * W/nf * 0.18u' pd='2*int((nf+1)/2) * (W/nf + 0.18u)' ps='2*int((nf+2)/2) * (W/nf + 0.18u)' nrd='0.18u / W' nrs='0.18u / W' sa=0 sb=0 sd=0
VR_m365 nref m365r 0
XO_m365 m365o m365r Vdd Vdd pfet_03v3 L=0.736u W=2.475u nf=1 ad='int((nf+1)/2) * W/nf * 0.18u' as='int((nf+2)/2) * W/nf * 0.18u' pd='2*int((nf+1)/2) * (W/nf + 0.18u)' ps='2*int((nf+2)/2) * (W/nf + 0.18u)' nrd='0.18u / W' nrs='0.18u / W' sa=0 sb=0 sd=0
VO_m365 m365o Vmem 0
XR_m366 m366r m366r Vdd Vdd pfet_03v3 L=0.315u W=1.603u nf=1 ad='int((nf+1)/2) * W/nf * 0.18u' as='int((nf+2)/2) * W/nf * 0.18u' pd='2*int((nf+1)/2) * (W/nf + 0.18u)' ps='2*int((nf+2)/2) * (W/nf + 0.18u)' nrd='0.18u / W' nrs='0.18u / W' sa=0 sb=0 sd=0
VR_m366 nref m366r 0
XO_m366 m366o m366r Vdd Vdd pfet_03v3 L=3.567u W=0.53u nf=1 ad='int((nf+1)/2) * W/nf * 0.18u' as='int((nf+2)/2) * W/nf * 0.18u' pd='2*int((nf+1)/2) * (W/nf + 0.18u)' ps='2*int((nf+2)/2) * (W/nf + 0.18u)' nrd='0.18u / W' nrs='0.18u / W' sa=0 sb=0 sd=0
VO_m366 m366o Vmem 0
XR_m367 m367r m367r Vdd Vdd pfet_03v3 L=0.88u W=0.608u nf=1 ad='int((nf+1)/2) * W/nf * 0.18u' as='int((nf+2)/2) * W/nf * 0.18u' pd='2*int((nf+1)/2) * (W/nf + 0.18u)' ps='2*int((nf+2)/2) * (W/nf + 0.18u)' nrd='0.18u / W' nrs='0.18u / W' sa=0 sb=0 sd=0
VR_m367 nref m367r 0
XO_m367 m367o m367r Vdd Vdd pfet_03v3 L=0.325u W=0.342u nf=1 ad='int((nf+1)/2) * W/nf * 0.18u' as='int((nf+2)/2) * W/nf * 0.18u' pd='2*int((nf+1)/2) * (W/nf + 0.18u)' ps='2*int((nf+2)/2) * (W/nf + 0.18u)' nrd='0.18u / W' nrs='0.18u / W' sa=0 sb=0 sd=0
VO_m367 m367o Vmem 0
XR_m368 m368r m368r Vdd Vdd pfet_03v3 L=0.544u W=0.248u nf=1 ad='int((nf+1)/2) * W/nf * 0.18u' as='int((nf+2)/2) * W/nf * 0.18u' pd='2*int((nf+1)/2) * (W/nf + 0.18u)' ps='2*int((nf+2)/2) * (W/nf + 0.18u)' nrd='0.18u / W' nrs='0.18u / W' sa=0 sb=0 sd=0
VR_m368 nref m368r 0
XO_m368 m368o m368r Vdd Vdd pfet_03v3 L=4.32u W=3.962u nf=1 ad='int((nf+1)/2) * W/nf * 0.18u' as='int((nf+2)/2) * W/nf * 0.18u' pd='2*int((nf+1)/2) * (W/nf + 0.18u)' ps='2*int((nf+2)/2) * (W/nf + 0.18u)' nrd='0.18u / W' nrs='0.18u / W' sa=0 sb=0 sd=0
VO_m368 m368o Vmem 0
XR_m369 m369r m369r Vdd Vdd pfet_03v3 L=1.911u W=0.226u nf=1 ad='int((nf+1)/2) * W/nf * 0.18u' as='int((nf+2)/2) * W/nf * 0.18u' pd='2*int((nf+1)/2) * (W/nf + 0.18u)' ps='2*int((nf+2)/2) * (W/nf + 0.18u)' nrd='0.18u / W' nrs='0.18u / W' sa=0 sb=0 sd=0
VR_m369 nref m369r 0
XO_m369 m369o m369r Vdd Vdd pfet_03v3 L=0.838u W=0.39u nf=1 ad='int((nf+1)/2) * W/nf * 0.18u' as='int((nf+2)/2) * W/nf * 0.18u' pd='2*int((nf+1)/2) * (W/nf + 0.18u)' ps='2*int((nf+2)/2) * (W/nf + 0.18u)' nrd='0.18u / W' nrs='0.18u / W' sa=0 sb=0 sd=0
VO_m369 m369o Vmem 0
XR_m370 m370r m370r Vdd Vdd pfet_03v3 L=0.808u W=0.253u nf=1 ad='int((nf+1)/2) * W/nf * 0.18u' as='int((nf+2)/2) * W/nf * 0.18u' pd='2*int((nf+1)/2) * (W/nf + 0.18u)' ps='2*int((nf+2)/2) * (W/nf + 0.18u)' nrd='0.18u / W' nrs='0.18u / W' sa=0 sb=0 sd=0
VR_m370 nref m370r 0
XO_m370 m370o m370r Vdd Vdd pfet_03v3 L=0.992u W=0.258u nf=1 ad='int((nf+1)/2) * W/nf * 0.18u' as='int((nf+2)/2) * W/nf * 0.18u' pd='2*int((nf+1)/2) * (W/nf + 0.18u)' ps='2*int((nf+2)/2) * (W/nf + 0.18u)' nrd='0.18u / W' nrs='0.18u / W' sa=0 sb=0 sd=0
VO_m370 m370o Vmem 0
XR_m371 m371r m371r Vdd Vdd pfet_03v3 L=0.288u W=0.711u nf=1 ad='int((nf+1)/2) * W/nf * 0.18u' as='int((nf+2)/2) * W/nf * 0.18u' pd='2*int((nf+1)/2) * (W/nf + 0.18u)' ps='2*int((nf+2)/2) * (W/nf + 0.18u)' nrd='0.18u / W' nrs='0.18u / W' sa=0 sb=0 sd=0
VR_m371 nref m371r 0
XO_m371 m371o m371r Vdd Vdd pfet_03v3 L=1.207u W=0.333u nf=1 ad='int((nf+1)/2) * W/nf * 0.18u' as='int((nf+2)/2) * W/nf * 0.18u' pd='2*int((nf+1)/2) * (W/nf + 0.18u)' ps='2*int((nf+2)/2) * (W/nf + 0.18u)' nrd='0.18u / W' nrs='0.18u / W' sa=0 sb=0 sd=0
VO_m371 m371o Vmem 0
XR_m372 m372r m372r Vdd Vdd pfet_03v3 L=0.386u W=0.559u nf=1 ad='int((nf+1)/2) * W/nf * 0.18u' as='int((nf+2)/2) * W/nf * 0.18u' pd='2*int((nf+1)/2) * (W/nf + 0.18u)' ps='2*int((nf+2)/2) * (W/nf + 0.18u)' nrd='0.18u / W' nrs='0.18u / W' sa=0 sb=0 sd=0
VR_m372 nref m372r 0
XO_m372 m372o m372r Vdd Vdd pfet_03v3 L=2.265u W=0.466u nf=1 ad='int((nf+1)/2) * W/nf * 0.18u' as='int((nf+2)/2) * W/nf * 0.18u' pd='2*int((nf+1)/2) * (W/nf + 0.18u)' ps='2*int((nf+2)/2) * (W/nf + 0.18u)' nrd='0.18u / W' nrs='0.18u / W' sa=0 sb=0 sd=0
VO_m372 m372o Vmem 0
XR_m373 m373r m373r Vdd Vdd pfet_03v3 L=1.045u W=0.803u nf=1 ad='int((nf+1)/2) * W/nf * 0.18u' as='int((nf+2)/2) * W/nf * 0.18u' pd='2*int((nf+1)/2) * (W/nf + 0.18u)' ps='2*int((nf+2)/2) * (W/nf + 0.18u)' nrd='0.18u / W' nrs='0.18u / W' sa=0 sb=0 sd=0
VR_m373 nref m373r 0
XO_m373 m373o m373r Vdd Vdd pfet_03v3 L=3.101u W=0.821u nf=1 ad='int((nf+1)/2) * W/nf * 0.18u' as='int((nf+2)/2) * W/nf * 0.18u' pd='2*int((nf+1)/2) * (W/nf + 0.18u)' ps='2*int((nf+2)/2) * (W/nf + 0.18u)' nrd='0.18u / W' nrs='0.18u / W' sa=0 sb=0 sd=0
VO_m373 m373o Vmem 0
XR_m374 m374r m374r Vdd Vdd pfet_03v3 L=1.618u W=2.452u nf=1 ad='int((nf+1)/2) * W/nf * 0.18u' as='int((nf+2)/2) * W/nf * 0.18u' pd='2*int((nf+1)/2) * (W/nf + 0.18u)' ps='2*int((nf+2)/2) * (W/nf + 0.18u)' nrd='0.18u / W' nrs='0.18u / W' sa=0 sb=0 sd=0
VR_m374 nref m374r 0
XO_m374 m374o m374r Vdd Vdd pfet_03v3 L=1.224u W=1.738u nf=1 ad='int((nf+1)/2) * W/nf * 0.18u' as='int((nf+2)/2) * W/nf * 0.18u' pd='2*int((nf+1)/2) * (W/nf + 0.18u)' ps='2*int((nf+2)/2) * (W/nf + 0.18u)' nrd='0.18u / W' nrs='0.18u / W' sa=0 sb=0 sd=0
VO_m374 m374o Vmem 0
XR_m375 m375r m375r Vdd Vdd pfet_03v3 L=1.801u W=0.979u nf=1 ad='int((nf+1)/2) * W/nf * 0.18u' as='int((nf+2)/2) * W/nf * 0.18u' pd='2*int((nf+1)/2) * (W/nf + 0.18u)' ps='2*int((nf+2)/2) * (W/nf + 0.18u)' nrd='0.18u / W' nrs='0.18u / W' sa=0 sb=0 sd=0
VR_m375 nref m375r 0
XO_m375 m375o m375r Vdd Vdd pfet_03v3 L=0.454u W=0.272u nf=1 ad='int((nf+1)/2) * W/nf * 0.18u' as='int((nf+2)/2) * W/nf * 0.18u' pd='2*int((nf+1)/2) * (W/nf + 0.18u)' ps='2*int((nf+2)/2) * (W/nf + 0.18u)' nrd='0.18u / W' nrs='0.18u / W' sa=0 sb=0 sd=0
VO_m375 m375o Vmem 0
XR_m376 m376r m376r Vdd Vdd pfet_03v3 L=1.253u W=0.734u nf=1 ad='int((nf+1)/2) * W/nf * 0.18u' as='int((nf+2)/2) * W/nf * 0.18u' pd='2*int((nf+1)/2) * (W/nf + 0.18u)' ps='2*int((nf+2)/2) * (W/nf + 0.18u)' nrd='0.18u / W' nrs='0.18u / W' sa=0 sb=0 sd=0
VR_m376 nref m376r 0
XO_m376 m376o m376r Vdd Vdd pfet_03v3 L=0.791u W=1.277u nf=1 ad='int((nf+1)/2) * W/nf * 0.18u' as='int((nf+2)/2) * W/nf * 0.18u' pd='2*int((nf+1)/2) * (W/nf + 0.18u)' ps='2*int((nf+2)/2) * (W/nf + 0.18u)' nrd='0.18u / W' nrs='0.18u / W' sa=0 sb=0 sd=0
VO_m376 m376o Vmem 0
XR_m377 m377r m377r Vdd Vdd pfet_03v3 L=1.22u W=0.892u nf=1 ad='int((nf+1)/2) * W/nf * 0.18u' as='int((nf+2)/2) * W/nf * 0.18u' pd='2*int((nf+1)/2) * (W/nf + 0.18u)' ps='2*int((nf+2)/2) * (W/nf + 0.18u)' nrd='0.18u / W' nrs='0.18u / W' sa=0 sb=0 sd=0
VR_m377 nref m377r 0
XO_m377 m377o m377r Vdd Vdd pfet_03v3 L=1.412u W=1.426u nf=1 ad='int((nf+1)/2) * W/nf * 0.18u' as='int((nf+2)/2) * W/nf * 0.18u' pd='2*int((nf+1)/2) * (W/nf + 0.18u)' ps='2*int((nf+2)/2) * (W/nf + 0.18u)' nrd='0.18u / W' nrs='0.18u / W' sa=0 sb=0 sd=0
VO_m377 m377o Vmem 0
XR_m378 m378r m378r Vdd Vdd pfet_03v3 L=1.096u W=2.458u nf=1 ad='int((nf+1)/2) * W/nf * 0.18u' as='int((nf+2)/2) * W/nf * 0.18u' pd='2*int((nf+1)/2) * (W/nf + 0.18u)' ps='2*int((nf+2)/2) * (W/nf + 0.18u)' nrd='0.18u / W' nrs='0.18u / W' sa=0 sb=0 sd=0
VR_m378 nref m378r 0
XO_m378 m378o m378r Vdd Vdd pfet_03v3 L=0.665u W=2.835u nf=1 ad='int((nf+1)/2) * W/nf * 0.18u' as='int((nf+2)/2) * W/nf * 0.18u' pd='2*int((nf+1)/2) * (W/nf + 0.18u)' ps='2*int((nf+2)/2) * (W/nf + 0.18u)' nrd='0.18u / W' nrs='0.18u / W' sa=0 sb=0 sd=0
VO_m378 m378o Vmem 0
XR_m379 m379r m379r Vdd Vdd pfet_03v3 L=0.759u W=0.53u nf=1 ad='int((nf+1)/2) * W/nf * 0.18u' as='int((nf+2)/2) * W/nf * 0.18u' pd='2*int((nf+1)/2) * (W/nf + 0.18u)' ps='2*int((nf+2)/2) * (W/nf + 0.18u)' nrd='0.18u / W' nrs='0.18u / W' sa=0 sb=0 sd=0
VR_m379 nref m379r 0
XO_m379 m379o m379r Vdd Vdd pfet_03v3 L=1.712u W=3.158u nf=1 ad='int((nf+1)/2) * W/nf * 0.18u' as='int((nf+2)/2) * W/nf * 0.18u' pd='2*int((nf+1)/2) * (W/nf + 0.18u)' ps='2*int((nf+2)/2) * (W/nf + 0.18u)' nrd='0.18u / W' nrs='0.18u / W' sa=0 sb=0 sd=0
VO_m379 m379o Vmem 0
XR_m380 m380r m380r Vdd Vdd pfet_03v3 L=0.568u W=1.223u nf=1 ad='int((nf+1)/2) * W/nf * 0.18u' as='int((nf+2)/2) * W/nf * 0.18u' pd='2*int((nf+1)/2) * (W/nf + 0.18u)' ps='2*int((nf+2)/2) * (W/nf + 0.18u)' nrd='0.18u / W' nrs='0.18u / W' sa=0 sb=0 sd=0
VR_m380 nref m380r 0
XO_m380 m380o m380r Vdd Vdd pfet_03v3 L=2.135u W=0.372u nf=1 ad='int((nf+1)/2) * W/nf * 0.18u' as='int((nf+2)/2) * W/nf * 0.18u' pd='2*int((nf+1)/2) * (W/nf + 0.18u)' ps='2*int((nf+2)/2) * (W/nf + 0.18u)' nrd='0.18u / W' nrs='0.18u / W' sa=0 sb=0 sd=0
VO_m380 m380o Vmem 0
XR_m381 m381r m381r Vdd Vdd pfet_03v3 L=0.473u W=2.353u nf=1 ad='int((nf+1)/2) * W/nf * 0.18u' as='int((nf+2)/2) * W/nf * 0.18u' pd='2*int((nf+1)/2) * (W/nf + 0.18u)' ps='2*int((nf+2)/2) * (W/nf + 0.18u)' nrd='0.18u / W' nrs='0.18u / W' sa=0 sb=0 sd=0
VR_m381 nref m381r 0
XO_m381 m381o m381r Vdd Vdd pfet_03v3 L=0.434u W=0.263u nf=1 ad='int((nf+1)/2) * W/nf * 0.18u' as='int((nf+2)/2) * W/nf * 0.18u' pd='2*int((nf+1)/2) * (W/nf + 0.18u)' ps='2*int((nf+2)/2) * (W/nf + 0.18u)' nrd='0.18u / W' nrs='0.18u / W' sa=0 sb=0 sd=0
VO_m381 m381o Vmem 0
XR_m382 m382r m382r Vdd Vdd pfet_03v3 L=0.543u W=0.406u nf=1 ad='int((nf+1)/2) * W/nf * 0.18u' as='int((nf+2)/2) * W/nf * 0.18u' pd='2*int((nf+1)/2) * (W/nf + 0.18u)' ps='2*int((nf+2)/2) * (W/nf + 0.18u)' nrd='0.18u / W' nrs='0.18u / W' sa=0 sb=0 sd=0
VR_m382 nref m382r 0
XO_m382 m382o m382r Vdd Vdd pfet_03v3 L=7.068u W=0.637u nf=1 ad='int((nf+1)/2) * W/nf * 0.18u' as='int((nf+2)/2) * W/nf * 0.18u' pd='2*int((nf+1)/2) * (W/nf + 0.18u)' ps='2*int((nf+2)/2) * (W/nf + 0.18u)' nrd='0.18u / W' nrs='0.18u / W' sa=0 sb=0 sd=0
VO_m382 m382o Vmem 0
XR_m383 m383r m383r Vdd Vdd pfet_03v3 L=1.107u W=3.149u nf=1 ad='int((nf+1)/2) * W/nf * 0.18u' as='int((nf+2)/2) * W/nf * 0.18u' pd='2*int((nf+1)/2) * (W/nf + 0.18u)' ps='2*int((nf+2)/2) * (W/nf + 0.18u)' nrd='0.18u / W' nrs='0.18u / W' sa=0 sb=0 sd=0
VR_m383 nref m383r 0
XO_m383 m383o m383r Vdd Vdd pfet_03v3 L=6.592u W=0.383u nf=1 ad='int((nf+1)/2) * W/nf * 0.18u' as='int((nf+2)/2) * W/nf * 0.18u' pd='2*int((nf+1)/2) * (W/nf + 0.18u)' ps='2*int((nf+2)/2) * (W/nf + 0.18u)' nrd='0.18u / W' nrs='0.18u / W' sa=0 sb=0 sd=0
VO_m383 m383o Vmem 0
XR_m384 m384r m384r Vdd Vdd pfet_03v3 L=0.62u W=2.788u nf=1 ad='int((nf+1)/2) * W/nf * 0.18u' as='int((nf+2)/2) * W/nf * 0.18u' pd='2*int((nf+1)/2) * (W/nf + 0.18u)' ps='2*int((nf+2)/2) * (W/nf + 0.18u)' nrd='0.18u / W' nrs='0.18u / W' sa=0 sb=0 sd=0
VR_m384 nref m384r 0
XO_m384 m384o m384r Vdd Vdd pfet_03v3 L=0.335u W=0.943u nf=1 ad='int((nf+1)/2) * W/nf * 0.18u' as='int((nf+2)/2) * W/nf * 0.18u' pd='2*int((nf+1)/2) * (W/nf + 0.18u)' ps='2*int((nf+2)/2) * (W/nf + 0.18u)' nrd='0.18u / W' nrs='0.18u / W' sa=0 sb=0 sd=0
VO_m384 m384o Vmem 0
XR_m385 m385r m385r Vdd Vdd pfet_03v3 L=3.383u W=2.781u nf=1 ad='int((nf+1)/2) * W/nf * 0.18u' as='int((nf+2)/2) * W/nf * 0.18u' pd='2*int((nf+1)/2) * (W/nf + 0.18u)' ps='2*int((nf+2)/2) * (W/nf + 0.18u)' nrd='0.18u / W' nrs='0.18u / W' sa=0 sb=0 sd=0
VR_m385 nref m385r 0
XO_m385 m385o m385r Vdd Vdd pfet_03v3 L=6.646u W=2.579u nf=1 ad='int((nf+1)/2) * W/nf * 0.18u' as='int((nf+2)/2) * W/nf * 0.18u' pd='2*int((nf+1)/2) * (W/nf + 0.18u)' ps='2*int((nf+2)/2) * (W/nf + 0.18u)' nrd='0.18u / W' nrs='0.18u / W' sa=0 sb=0 sd=0
VO_m385 m385o Vmem 0
XR_m386 m386r m386r Vdd Vdd pfet_03v3 L=1.534u W=2.152u nf=1 ad='int((nf+1)/2) * W/nf * 0.18u' as='int((nf+2)/2) * W/nf * 0.18u' pd='2*int((nf+1)/2) * (W/nf + 0.18u)' ps='2*int((nf+2)/2) * (W/nf + 0.18u)' nrd='0.18u / W' nrs='0.18u / W' sa=0 sb=0 sd=0
VR_m386 nref m386r 0
XO_m386 m386o m386r Vdd Vdd pfet_03v3 L=0.47u W=2.708u nf=1 ad='int((nf+1)/2) * W/nf * 0.18u' as='int((nf+2)/2) * W/nf * 0.18u' pd='2*int((nf+1)/2) * (W/nf + 0.18u)' ps='2*int((nf+2)/2) * (W/nf + 0.18u)' nrd='0.18u / W' nrs='0.18u / W' sa=0 sb=0 sd=0
VO_m386 m386o Vmem 0
XR_m387 m387r m387r Vdd Vdd pfet_03v3 L=3.101u W=3.885u nf=1 ad='int((nf+1)/2) * W/nf * 0.18u' as='int((nf+2)/2) * W/nf * 0.18u' pd='2*int((nf+1)/2) * (W/nf + 0.18u)' ps='2*int((nf+2)/2) * (W/nf + 0.18u)' nrd='0.18u / W' nrs='0.18u / W' sa=0 sb=0 sd=0
VR_m387 nref m387r 0
XO_m387 m387o m387r Vdd Vdd pfet_03v3 L=1.581u W=2.277u nf=1 ad='int((nf+1)/2) * W/nf * 0.18u' as='int((nf+2)/2) * W/nf * 0.18u' pd='2*int((nf+1)/2) * (W/nf + 0.18u)' ps='2*int((nf+2)/2) * (W/nf + 0.18u)' nrd='0.18u / W' nrs='0.18u / W' sa=0 sb=0 sd=0
VO_m387 m387o Vmem 0
XR_m388 m388r m388r Vdd Vdd pfet_03v3 L=1.578u W=0.597u nf=1 ad='int((nf+1)/2) * W/nf * 0.18u' as='int((nf+2)/2) * W/nf * 0.18u' pd='2*int((nf+1)/2) * (W/nf + 0.18u)' ps='2*int((nf+2)/2) * (W/nf + 0.18u)' nrd='0.18u / W' nrs='0.18u / W' sa=0 sb=0 sd=0
VR_m388 nref m388r 0
XO_m388 m388o m388r Vdd Vdd pfet_03v3 L=0.719u W=0.365u nf=1 ad='int((nf+1)/2) * W/nf * 0.18u' as='int((nf+2)/2) * W/nf * 0.18u' pd='2*int((nf+1)/2) * (W/nf + 0.18u)' ps='2*int((nf+2)/2) * (W/nf + 0.18u)' nrd='0.18u / W' nrs='0.18u / W' sa=0 sb=0 sd=0
VO_m388 m388o Vmem 0
XR_m389 m389r m389r Vdd Vdd pfet_03v3 L=0.779u W=0.326u nf=1 ad='int((nf+1)/2) * W/nf * 0.18u' as='int((nf+2)/2) * W/nf * 0.18u' pd='2*int((nf+1)/2) * (W/nf + 0.18u)' ps='2*int((nf+2)/2) * (W/nf + 0.18u)' nrd='0.18u / W' nrs='0.18u / W' sa=0 sb=0 sd=0
VR_m389 nref m389r 0
XO_m389 m389o m389r Vdd Vdd pfet_03v3 L=3.499u W=1.731u nf=1 ad='int((nf+1)/2) * W/nf * 0.18u' as='int((nf+2)/2) * W/nf * 0.18u' pd='2*int((nf+1)/2) * (W/nf + 0.18u)' ps='2*int((nf+2)/2) * (W/nf + 0.18u)' nrd='0.18u / W' nrs='0.18u / W' sa=0 sb=0 sd=0
VO_m389 m389o Vmem 0
XR_m390 m390r m390r Vdd Vdd pfet_03v3 L=0.468u W=1.652u nf=1 ad='int((nf+1)/2) * W/nf * 0.18u' as='int((nf+2)/2) * W/nf * 0.18u' pd='2*int((nf+1)/2) * (W/nf + 0.18u)' ps='2*int((nf+2)/2) * (W/nf + 0.18u)' nrd='0.18u / W' nrs='0.18u / W' sa=0 sb=0 sd=0
VR_m390 nref m390r 0
XO_m390 m390o m390r Vdd Vdd pfet_03v3 L=2.199u W=0.333u nf=1 ad='int((nf+1)/2) * W/nf * 0.18u' as='int((nf+2)/2) * W/nf * 0.18u' pd='2*int((nf+1)/2) * (W/nf + 0.18u)' ps='2*int((nf+2)/2) * (W/nf + 0.18u)' nrd='0.18u / W' nrs='0.18u / W' sa=0 sb=0 sd=0
VO_m390 m390o Vmem 0
XR_m391 m391r m391r Vdd Vdd pfet_03v3 L=1.888u W=0.714u nf=1 ad='int((nf+1)/2) * W/nf * 0.18u' as='int((nf+2)/2) * W/nf * 0.18u' pd='2*int((nf+1)/2) * (W/nf + 0.18u)' ps='2*int((nf+2)/2) * (W/nf + 0.18u)' nrd='0.18u / W' nrs='0.18u / W' sa=0 sb=0 sd=0
VR_m391 nref m391r 0
XO_m391 m391o m391r Vdd Vdd pfet_03v3 L=2.749u W=0.733u nf=1 ad='int((nf+1)/2) * W/nf * 0.18u' as='int((nf+2)/2) * W/nf * 0.18u' pd='2*int((nf+1)/2) * (W/nf + 0.18u)' ps='2*int((nf+2)/2) * (W/nf + 0.18u)' nrd='0.18u / W' nrs='0.18u / W' sa=0 sb=0 sd=0
VO_m391 m391o Vmem 0
XR_m392 m392r m392r Vdd Vdd pfet_03v3 L=1.863u W=0.997u nf=1 ad='int((nf+1)/2) * W/nf * 0.18u' as='int((nf+2)/2) * W/nf * 0.18u' pd='2*int((nf+1)/2) * (W/nf + 0.18u)' ps='2*int((nf+2)/2) * (W/nf + 0.18u)' nrd='0.18u / W' nrs='0.18u / W' sa=0 sb=0 sd=0
VR_m392 nref m392r 0
XO_m392 m392o m392r Vdd Vdd pfet_03v3 L=0.509u W=2.425u nf=1 ad='int((nf+1)/2) * W/nf * 0.18u' as='int((nf+2)/2) * W/nf * 0.18u' pd='2*int((nf+1)/2) * (W/nf + 0.18u)' ps='2*int((nf+2)/2) * (W/nf + 0.18u)' nrd='0.18u / W' nrs='0.18u / W' sa=0 sb=0 sd=0
VO_m392 m392o Vmem 0
XR_m393 m393r m393r Vdd Vdd pfet_03v3 L=0.808u W=2.735u nf=1 ad='int((nf+1)/2) * W/nf * 0.18u' as='int((nf+2)/2) * W/nf * 0.18u' pd='2*int((nf+1)/2) * (W/nf + 0.18u)' ps='2*int((nf+2)/2) * (W/nf + 0.18u)' nrd='0.18u / W' nrs='0.18u / W' sa=0 sb=0 sd=0
VR_m393 nref m393r 0
XO_m393 m393o m393r Vdd Vdd pfet_03v3 L=2.139u W=0.347u nf=1 ad='int((nf+1)/2) * W/nf * 0.18u' as='int((nf+2)/2) * W/nf * 0.18u' pd='2*int((nf+1)/2) * (W/nf + 0.18u)' ps='2*int((nf+2)/2) * (W/nf + 0.18u)' nrd='0.18u / W' nrs='0.18u / W' sa=0 sb=0 sd=0
VO_m393 m393o Vmem 0
XR_m394 m394r m394r Vdd Vdd pfet_03v3 L=0.415u W=1.818u nf=1 ad='int((nf+1)/2) * W/nf * 0.18u' as='int((nf+2)/2) * W/nf * 0.18u' pd='2*int((nf+1)/2) * (W/nf + 0.18u)' ps='2*int((nf+2)/2) * (W/nf + 0.18u)' nrd='0.18u / W' nrs='0.18u / W' sa=0 sb=0 sd=0
VR_m394 nref m394r 0
XO_m394 m394o m394r Vdd Vdd pfet_03v3 L=1.391u W=0.265u nf=1 ad='int((nf+1)/2) * W/nf * 0.18u' as='int((nf+2)/2) * W/nf * 0.18u' pd='2*int((nf+1)/2) * (W/nf + 0.18u)' ps='2*int((nf+2)/2) * (W/nf + 0.18u)' nrd='0.18u / W' nrs='0.18u / W' sa=0 sb=0 sd=0
VO_m394 m394o Vmem 0
XR_m395 m395r m395r Vdd Vdd pfet_03v3 L=2.615u W=0.41u nf=1 ad='int((nf+1)/2) * W/nf * 0.18u' as='int((nf+2)/2) * W/nf * 0.18u' pd='2*int((nf+1)/2) * (W/nf + 0.18u)' ps='2*int((nf+2)/2) * (W/nf + 0.18u)' nrd='0.18u / W' nrs='0.18u / W' sa=0 sb=0 sd=0
VR_m395 nref m395r 0
XO_m395 m395o m395r Vdd Vdd pfet_03v3 L=7.807u W=0.827u nf=1 ad='int((nf+1)/2) * W/nf * 0.18u' as='int((nf+2)/2) * W/nf * 0.18u' pd='2*int((nf+1)/2) * (W/nf + 0.18u)' ps='2*int((nf+2)/2) * (W/nf + 0.18u)' nrd='0.18u / W' nrs='0.18u / W' sa=0 sb=0 sd=0
VO_m395 m395o Vmem 0
XR_m396 m396r m396r Vdd Vdd pfet_03v3 L=0.452u W=0.788u nf=1 ad='int((nf+1)/2) * W/nf * 0.18u' as='int((nf+2)/2) * W/nf * 0.18u' pd='2*int((nf+1)/2) * (W/nf + 0.18u)' ps='2*int((nf+2)/2) * (W/nf + 0.18u)' nrd='0.18u / W' nrs='0.18u / W' sa=0 sb=0 sd=0
VR_m396 nref m396r 0
XO_m396 m396o m396r Vdd Vdd pfet_03v3 L=0.679u W=0.334u nf=1 ad='int((nf+1)/2) * W/nf * 0.18u' as='int((nf+2)/2) * W/nf * 0.18u' pd='2*int((nf+1)/2) * (W/nf + 0.18u)' ps='2*int((nf+2)/2) * (W/nf + 0.18u)' nrd='0.18u / W' nrs='0.18u / W' sa=0 sb=0 sd=0
VO_m396 m396o Vmem 0
XR_m397 m397r m397r Vdd Vdd pfet_03v3 L=0.711u W=1.419u nf=1 ad='int((nf+1)/2) * W/nf * 0.18u' as='int((nf+2)/2) * W/nf * 0.18u' pd='2*int((nf+1)/2) * (W/nf + 0.18u)' ps='2*int((nf+2)/2) * (W/nf + 0.18u)' nrd='0.18u / W' nrs='0.18u / W' sa=0 sb=0 sd=0
VR_m397 nref m397r 0
XO_m397 m397o m397r Vdd Vdd pfet_03v3 L=4.528u W=0.652u nf=1 ad='int((nf+1)/2) * W/nf * 0.18u' as='int((nf+2)/2) * W/nf * 0.18u' pd='2*int((nf+1)/2) * (W/nf + 0.18u)' ps='2*int((nf+2)/2) * (W/nf + 0.18u)' nrd='0.18u / W' nrs='0.18u / W' sa=0 sb=0 sd=0
VO_m397 m397o Vmem 0
XR_m398 m398r m398r Vdd Vdd pfet_03v3 L=3.432u W=2.634u nf=1 ad='int((nf+1)/2) * W/nf * 0.18u' as='int((nf+2)/2) * W/nf * 0.18u' pd='2*int((nf+1)/2) * (W/nf + 0.18u)' ps='2*int((nf+2)/2) * (W/nf + 0.18u)' nrd='0.18u / W' nrs='0.18u / W' sa=0 sb=0 sd=0
VR_m398 nref m398r 0
XO_m398 m398o m398r Vdd Vdd pfet_03v3 L=0.721u W=0.405u nf=1 ad='int((nf+1)/2) * W/nf * 0.18u' as='int((nf+2)/2) * W/nf * 0.18u' pd='2*int((nf+1)/2) * (W/nf + 0.18u)' ps='2*int((nf+2)/2) * (W/nf + 0.18u)' nrd='0.18u / W' nrs='0.18u / W' sa=0 sb=0 sd=0
VO_m398 m398o Vmem 0
XR_m399 m399r m399r Vdd Vdd pfet_03v3 L=3.336u W=0.901u nf=1 ad='int((nf+1)/2) * W/nf * 0.18u' as='int((nf+2)/2) * W/nf * 0.18u' pd='2*int((nf+1)/2) * (W/nf + 0.18u)' ps='2*int((nf+2)/2) * (W/nf + 0.18u)' nrd='0.18u / W' nrs='0.18u / W' sa=0 sb=0 sd=0
VR_m399 nref m399r 0
XO_m399 m399o m399r Vdd Vdd pfet_03v3 L=5.93u W=0.413u nf=1 ad='int((nf+1)/2) * W/nf * 0.18u' as='int((nf+2)/2) * W/nf * 0.18u' pd='2*int((nf+1)/2) * (W/nf + 0.18u)' ps='2*int((nf+2)/2) * (W/nf + 0.18u)' nrd='0.18u / W' nrs='0.18u / W' sa=0 sb=0 sd=0
VO_m399 m399o Vmem 0
XR_m400 m400r m400r Vdd Vdd pfet_03v3 L=3.255u W=1.082u nf=1 ad='int((nf+1)/2) * W/nf * 0.18u' as='int((nf+2)/2) * W/nf * 0.18u' pd='2*int((nf+1)/2) * (W/nf + 0.18u)' ps='2*int((nf+2)/2) * (W/nf + 0.18u)' nrd='0.18u / W' nrs='0.18u / W' sa=0 sb=0 sd=0
VR_m400 nref m400r 0
XO_m400 m400o m400r Vdd Vdd pfet_03v3 L=6.098u W=1.438u nf=1 ad='int((nf+1)/2) * W/nf * 0.18u' as='int((nf+2)/2) * W/nf * 0.18u' pd='2*int((nf+1)/2) * (W/nf + 0.18u)' ps='2*int((nf+2)/2) * (W/nf + 0.18u)' nrd='0.18u / W' nrs='0.18u / W' sa=0 sb=0 sd=0
VO_m400 m400o Vmem 0
XR_m401 m401r m401r Vdd Vdd pfet_03v3 L=2.208u W=0.635u nf=1 ad='int((nf+1)/2) * W/nf * 0.18u' as='int((nf+2)/2) * W/nf * 0.18u' pd='2*int((nf+1)/2) * (W/nf + 0.18u)' ps='2*int((nf+2)/2) * (W/nf + 0.18u)' nrd='0.18u / W' nrs='0.18u / W' sa=0 sb=0 sd=0
VR_m401 nref m401r 0
XO_m401 m401o m401r Vdd Vdd pfet_03v3 L=0.791u W=2.715u nf=1 ad='int((nf+1)/2) * W/nf * 0.18u' as='int((nf+2)/2) * W/nf * 0.18u' pd='2*int((nf+1)/2) * (W/nf + 0.18u)' ps='2*int((nf+2)/2) * (W/nf + 0.18u)' nrd='0.18u / W' nrs='0.18u / W' sa=0 sb=0 sd=0
VO_m401 m401o Vmem 0
XR_m402 m402r m402r Vdd Vdd pfet_03v3 L=1.972u W=0.227u nf=1 ad='int((nf+1)/2) * W/nf * 0.18u' as='int((nf+2)/2) * W/nf * 0.18u' pd='2*int((nf+1)/2) * (W/nf + 0.18u)' ps='2*int((nf+2)/2) * (W/nf + 0.18u)' nrd='0.18u / W' nrs='0.18u / W' sa=0 sb=0 sd=0
VR_m402 nref m402r 0
XO_m402 m402o m402r Vdd Vdd pfet_03v3 L=2.955u W=3.906u nf=1 ad='int((nf+1)/2) * W/nf * 0.18u' as='int((nf+2)/2) * W/nf * 0.18u' pd='2*int((nf+1)/2) * (W/nf + 0.18u)' ps='2*int((nf+2)/2) * (W/nf + 0.18u)' nrd='0.18u / W' nrs='0.18u / W' sa=0 sb=0 sd=0
VO_m402 m402o Vmem 0
XR_m403 m403r m403r Vdd Vdd pfet_03v3 L=0.457u W=0.257u nf=1 ad='int((nf+1)/2) * W/nf * 0.18u' as='int((nf+2)/2) * W/nf * 0.18u' pd='2*int((nf+1)/2) * (W/nf + 0.18u)' ps='2*int((nf+2)/2) * (W/nf + 0.18u)' nrd='0.18u / W' nrs='0.18u / W' sa=0 sb=0 sd=0
VR_m403 nref m403r 0
XO_m403 m403o m403r Vdd Vdd pfet_03v3 L=0.923u W=2.328u nf=1 ad='int((nf+1)/2) * W/nf * 0.18u' as='int((nf+2)/2) * W/nf * 0.18u' pd='2*int((nf+1)/2) * (W/nf + 0.18u)' ps='2*int((nf+2)/2) * (W/nf + 0.18u)' nrd='0.18u / W' nrs='0.18u / W' sa=0 sb=0 sd=0
VO_m403 m403o Vmem 0
XR_m404 m404r m404r Vdd Vdd pfet_03v3 L=0.591u W=1.542u nf=1 ad='int((nf+1)/2) * W/nf * 0.18u' as='int((nf+2)/2) * W/nf * 0.18u' pd='2*int((nf+1)/2) * (W/nf + 0.18u)' ps='2*int((nf+2)/2) * (W/nf + 0.18u)' nrd='0.18u / W' nrs='0.18u / W' sa=0 sb=0 sd=0
VR_m404 nref m404r 0
XO_m404 m404o m404r Vdd Vdd pfet_03v3 L=1.078u W=0.236u nf=1 ad='int((nf+1)/2) * W/nf * 0.18u' as='int((nf+2)/2) * W/nf * 0.18u' pd='2*int((nf+1)/2) * (W/nf + 0.18u)' ps='2*int((nf+2)/2) * (W/nf + 0.18u)' nrd='0.18u / W' nrs='0.18u / W' sa=0 sb=0 sd=0
VO_m404 m404o Vmem 0
XR_m405 m405r m405r Vdd Vdd pfet_03v3 L=1.949u W=0.98u nf=1 ad='int((nf+1)/2) * W/nf * 0.18u' as='int((nf+2)/2) * W/nf * 0.18u' pd='2*int((nf+1)/2) * (W/nf + 0.18u)' ps='2*int((nf+2)/2) * (W/nf + 0.18u)' nrd='0.18u / W' nrs='0.18u / W' sa=0 sb=0 sd=0
VR_m405 nref m405r 0
XO_m405 m405o m405r Vdd Vdd pfet_03v3 L=0.701u W=2.79u nf=1 ad='int((nf+1)/2) * W/nf * 0.18u' as='int((nf+2)/2) * W/nf * 0.18u' pd='2*int((nf+1)/2) * (W/nf + 0.18u)' ps='2*int((nf+2)/2) * (W/nf + 0.18u)' nrd='0.18u / W' nrs='0.18u / W' sa=0 sb=0 sd=0
VO_m405 m405o Vmem 0
XR_m406 m406r m406r Vdd Vdd pfet_03v3 L=1.172u W=0.921u nf=1 ad='int((nf+1)/2) * W/nf * 0.18u' as='int((nf+2)/2) * W/nf * 0.18u' pd='2*int((nf+1)/2) * (W/nf + 0.18u)' ps='2*int((nf+2)/2) * (W/nf + 0.18u)' nrd='0.18u / W' nrs='0.18u / W' sa=0 sb=0 sd=0
VR_m406 nref m406r 0
XO_m406 m406o m406r Vdd Vdd pfet_03v3 L=0.99u W=2.136u nf=1 ad='int((nf+1)/2) * W/nf * 0.18u' as='int((nf+2)/2) * W/nf * 0.18u' pd='2*int((nf+1)/2) * (W/nf + 0.18u)' ps='2*int((nf+2)/2) * (W/nf + 0.18u)' nrd='0.18u / W' nrs='0.18u / W' sa=0 sb=0 sd=0
VO_m406 m406o Vmem 0
XR_m407 m407r m407r Vdd Vdd pfet_03v3 L=0.517u W=3.27u nf=1 ad='int((nf+1)/2) * W/nf * 0.18u' as='int((nf+2)/2) * W/nf * 0.18u' pd='2*int((nf+1)/2) * (W/nf + 0.18u)' ps='2*int((nf+2)/2) * (W/nf + 0.18u)' nrd='0.18u / W' nrs='0.18u / W' sa=0 sb=0 sd=0
VR_m407 nref m407r 0
XO_m407 m407o m407r Vdd Vdd pfet_03v3 L=0.839u W=1.038u nf=1 ad='int((nf+1)/2) * W/nf * 0.18u' as='int((nf+2)/2) * W/nf * 0.18u' pd='2*int((nf+1)/2) * (W/nf + 0.18u)' ps='2*int((nf+2)/2) * (W/nf + 0.18u)' nrd='0.18u / W' nrs='0.18u / W' sa=0 sb=0 sd=0
VO_m407 m407o Vmem 0
XR_m408 m408r m408r Vdd Vdd pfet_03v3 L=0.34u W=0.476u nf=1 ad='int((nf+1)/2) * W/nf * 0.18u' as='int((nf+2)/2) * W/nf * 0.18u' pd='2*int((nf+1)/2) * (W/nf + 0.18u)' ps='2*int((nf+2)/2) * (W/nf + 0.18u)' nrd='0.18u / W' nrs='0.18u / W' sa=0 sb=0 sd=0
VR_m408 nref m408r 0
XO_m408 m408o m408r Vdd Vdd pfet_03v3 L=7.958u W=0.874u nf=1 ad='int((nf+1)/2) * W/nf * 0.18u' as='int((nf+2)/2) * W/nf * 0.18u' pd='2*int((nf+1)/2) * (W/nf + 0.18u)' ps='2*int((nf+2)/2) * (W/nf + 0.18u)' nrd='0.18u / W' nrs='0.18u / W' sa=0 sb=0 sd=0
VO_m408 m408o Vmem 0
XR_m409 m409r m409r Vdd Vdd pfet_03v3 L=1.129u W=2.217u nf=1 ad='int((nf+1)/2) * W/nf * 0.18u' as='int((nf+2)/2) * W/nf * 0.18u' pd='2*int((nf+1)/2) * (W/nf + 0.18u)' ps='2*int((nf+2)/2) * (W/nf + 0.18u)' nrd='0.18u / W' nrs='0.18u / W' sa=0 sb=0 sd=0
VR_m409 nref m409r 0
XO_m409 m409o m409r Vdd Vdd pfet_03v3 L=6.802u W=2.385u nf=1 ad='int((nf+1)/2) * W/nf * 0.18u' as='int((nf+2)/2) * W/nf * 0.18u' pd='2*int((nf+1)/2) * (W/nf + 0.18u)' ps='2*int((nf+2)/2) * (W/nf + 0.18u)' nrd='0.18u / W' nrs='0.18u / W' sa=0 sb=0 sd=0
VO_m409 m409o Vmem 0
XR_m410 m410r m410r Vdd Vdd pfet_03v3 L=0.285u W=0.291u nf=1 ad='int((nf+1)/2) * W/nf * 0.18u' as='int((nf+2)/2) * W/nf * 0.18u' pd='2*int((nf+1)/2) * (W/nf + 0.18u)' ps='2*int((nf+2)/2) * (W/nf + 0.18u)' nrd='0.18u / W' nrs='0.18u / W' sa=0 sb=0 sd=0
VR_m410 nref m410r 0
XO_m410 m410o m410r Vdd Vdd pfet_03v3 L=4.446u W=2.262u nf=1 ad='int((nf+1)/2) * W/nf * 0.18u' as='int((nf+2)/2) * W/nf * 0.18u' pd='2*int((nf+1)/2) * (W/nf + 0.18u)' ps='2*int((nf+2)/2) * (W/nf + 0.18u)' nrd='0.18u / W' nrs='0.18u / W' sa=0 sb=0 sd=0
VO_m410 m410o Vmem 0
XR_m411 m411r m411r Vdd Vdd pfet_03v3 L=0.296u W=0.227u nf=1 ad='int((nf+1)/2) * W/nf * 0.18u' as='int((nf+2)/2) * W/nf * 0.18u' pd='2*int((nf+1)/2) * (W/nf + 0.18u)' ps='2*int((nf+2)/2) * (W/nf + 0.18u)' nrd='0.18u / W' nrs='0.18u / W' sa=0 sb=0 sd=0
VR_m411 nref m411r 0
XO_m411 m411o m411r Vdd Vdd pfet_03v3 L=3.968u W=1.715u nf=1 ad='int((nf+1)/2) * W/nf * 0.18u' as='int((nf+2)/2) * W/nf * 0.18u' pd='2*int((nf+1)/2) * (W/nf + 0.18u)' ps='2*int((nf+2)/2) * (W/nf + 0.18u)' nrd='0.18u / W' nrs='0.18u / W' sa=0 sb=0 sd=0
VO_m411 m411o Vmem 0
XR_m412 m412r m412r Vdd Vdd pfet_03v3 L=0.837u W=3.6u nf=1 ad='int((nf+1)/2) * W/nf * 0.18u' as='int((nf+2)/2) * W/nf * 0.18u' pd='2*int((nf+1)/2) * (W/nf + 0.18u)' ps='2*int((nf+2)/2) * (W/nf + 0.18u)' nrd='0.18u / W' nrs='0.18u / W' sa=0 sb=0 sd=0
VR_m412 nref m412r 0
XO_m412 m412o m412r Vdd Vdd pfet_03v3 L=0.466u W=0.25u nf=1 ad='int((nf+1)/2) * W/nf * 0.18u' as='int((nf+2)/2) * W/nf * 0.18u' pd='2*int((nf+1)/2) * (W/nf + 0.18u)' ps='2*int((nf+2)/2) * (W/nf + 0.18u)' nrd='0.18u / W' nrs='0.18u / W' sa=0 sb=0 sd=0
VO_m412 m412o Vmem 0
XR_m413 m413r m413r Vdd Vdd pfet_03v3 L=1.042u W=0.593u nf=1 ad='int((nf+1)/2) * W/nf * 0.18u' as='int((nf+2)/2) * W/nf * 0.18u' pd='2*int((nf+1)/2) * (W/nf + 0.18u)' ps='2*int((nf+2)/2) * (W/nf + 0.18u)' nrd='0.18u / W' nrs='0.18u / W' sa=0 sb=0 sd=0
VR_m413 nref m413r 0
XO_m413 m413o m413r Vdd Vdd pfet_03v3 L=3.905u W=0.431u nf=1 ad='int((nf+1)/2) * W/nf * 0.18u' as='int((nf+2)/2) * W/nf * 0.18u' pd='2*int((nf+1)/2) * (W/nf + 0.18u)' ps='2*int((nf+2)/2) * (W/nf + 0.18u)' nrd='0.18u / W' nrs='0.18u / W' sa=0 sb=0 sd=0
VO_m413 m413o Vmem 0
XR_m414 m414r m414r Vdd Vdd pfet_03v3 L=0.656u W=0.256u nf=1 ad='int((nf+1)/2) * W/nf * 0.18u' as='int((nf+2)/2) * W/nf * 0.18u' pd='2*int((nf+1)/2) * (W/nf + 0.18u)' ps='2*int((nf+2)/2) * (W/nf + 0.18u)' nrd='0.18u / W' nrs='0.18u / W' sa=0 sb=0 sd=0
VR_m414 nref m414r 0
XO_m414 m414o m414r Vdd Vdd pfet_03v3 L=3.746u W=0.274u nf=1 ad='int((nf+1)/2) * W/nf * 0.18u' as='int((nf+2)/2) * W/nf * 0.18u' pd='2*int((nf+1)/2) * (W/nf + 0.18u)' ps='2*int((nf+2)/2) * (W/nf + 0.18u)' nrd='0.18u / W' nrs='0.18u / W' sa=0 sb=0 sd=0
VO_m414 m414o Vmem 0
XR_m415 m415r m415r Vdd Vdd pfet_03v3 L=0.377u W=0.383u nf=1 ad='int((nf+1)/2) * W/nf * 0.18u' as='int((nf+2)/2) * W/nf * 0.18u' pd='2*int((nf+1)/2) * (W/nf + 0.18u)' ps='2*int((nf+2)/2) * (W/nf + 0.18u)' nrd='0.18u / W' nrs='0.18u / W' sa=0 sb=0 sd=0
VR_m415 nref m415r 0
XO_m415 m415o m415r Vdd Vdd pfet_03v3 L=4.203u W=3.271u nf=1 ad='int((nf+1)/2) * W/nf * 0.18u' as='int((nf+2)/2) * W/nf * 0.18u' pd='2*int((nf+1)/2) * (W/nf + 0.18u)' ps='2*int((nf+2)/2) * (W/nf + 0.18u)' nrd='0.18u / W' nrs='0.18u / W' sa=0 sb=0 sd=0
VO_m415 m415o Vmem 0
XR_m416 m416r m416r Vdd Vdd pfet_03v3 L=0.688u W=1.432u nf=1 ad='int((nf+1)/2) * W/nf * 0.18u' as='int((nf+2)/2) * W/nf * 0.18u' pd='2*int((nf+1)/2) * (W/nf + 0.18u)' ps='2*int((nf+2)/2) * (W/nf + 0.18u)' nrd='0.18u / W' nrs='0.18u / W' sa=0 sb=0 sd=0
VR_m416 nref m416r 0
XO_m416 m416o m416r Vdd Vdd pfet_03v3 L=2.438u W=2.696u nf=1 ad='int((nf+1)/2) * W/nf * 0.18u' as='int((nf+2)/2) * W/nf * 0.18u' pd='2*int((nf+1)/2) * (W/nf + 0.18u)' ps='2*int((nf+2)/2) * (W/nf + 0.18u)' nrd='0.18u / W' nrs='0.18u / W' sa=0 sb=0 sd=0
VO_m416 m416o Vmem 0
XR_m417 m417r m417r Vdd Vdd pfet_03v3 L=0.449u W=1.672u nf=1 ad='int((nf+1)/2) * W/nf * 0.18u' as='int((nf+2)/2) * W/nf * 0.18u' pd='2*int((nf+1)/2) * (W/nf + 0.18u)' ps='2*int((nf+2)/2) * (W/nf + 0.18u)' nrd='0.18u / W' nrs='0.18u / W' sa=0 sb=0 sd=0
VR_m417 nref m417r 0
XO_m417 m417o m417r Vdd Vdd pfet_03v3 L=0.394u W=1.854u nf=1 ad='int((nf+1)/2) * W/nf * 0.18u' as='int((nf+2)/2) * W/nf * 0.18u' pd='2*int((nf+1)/2) * (W/nf + 0.18u)' ps='2*int((nf+2)/2) * (W/nf + 0.18u)' nrd='0.18u / W' nrs='0.18u / W' sa=0 sb=0 sd=0
VO_m417 m417o Vmem 0
XR_m418 m418r m418r Vdd Vdd pfet_03v3 L=0.334u W=3.063u nf=1 ad='int((nf+1)/2) * W/nf * 0.18u' as='int((nf+2)/2) * W/nf * 0.18u' pd='2*int((nf+1)/2) * (W/nf + 0.18u)' ps='2*int((nf+2)/2) * (W/nf + 0.18u)' nrd='0.18u / W' nrs='0.18u / W' sa=0 sb=0 sd=0
VR_m418 nref m418r 0
XO_m418 m418o m418r Vdd Vdd pfet_03v3 L=7.445u W=2.113u nf=1 ad='int((nf+1)/2) * W/nf * 0.18u' as='int((nf+2)/2) * W/nf * 0.18u' pd='2*int((nf+1)/2) * (W/nf + 0.18u)' ps='2*int((nf+2)/2) * (W/nf + 0.18u)' nrd='0.18u / W' nrs='0.18u / W' sa=0 sb=0 sd=0
VO_m418 m418o Vmem 0
XR_m419 m419r m419r Vdd Vdd pfet_03v3 L=0.857u W=0.36u nf=1 ad='int((nf+1)/2) * W/nf * 0.18u' as='int((nf+2)/2) * W/nf * 0.18u' pd='2*int((nf+1)/2) * (W/nf + 0.18u)' ps='2*int((nf+2)/2) * (W/nf + 0.18u)' nrd='0.18u / W' nrs='0.18u / W' sa=0 sb=0 sd=0
VR_m419 nref m419r 0
XO_m419 m419o m419r Vdd Vdd pfet_03v3 L=0.542u W=1.238u nf=1 ad='int((nf+1)/2) * W/nf * 0.18u' as='int((nf+2)/2) * W/nf * 0.18u' pd='2*int((nf+1)/2) * (W/nf + 0.18u)' ps='2*int((nf+2)/2) * (W/nf + 0.18u)' nrd='0.18u / W' nrs='0.18u / W' sa=0 sb=0 sd=0
VO_m419 m419o Vmem 0
XR_m420 m420r m420r Vdd Vdd pfet_03v3 L=0.804u W=0.659u nf=1 ad='int((nf+1)/2) * W/nf * 0.18u' as='int((nf+2)/2) * W/nf * 0.18u' pd='2*int((nf+1)/2) * (W/nf + 0.18u)' ps='2*int((nf+2)/2) * (W/nf + 0.18u)' nrd='0.18u / W' nrs='0.18u / W' sa=0 sb=0 sd=0
VR_m420 nref m420r 0
XO_m420 m420o m420r Vdd Vdd pfet_03v3 L=5.546u W=3.696u nf=1 ad='int((nf+1)/2) * W/nf * 0.18u' as='int((nf+2)/2) * W/nf * 0.18u' pd='2*int((nf+1)/2) * (W/nf + 0.18u)' ps='2*int((nf+2)/2) * (W/nf + 0.18u)' nrd='0.18u / W' nrs='0.18u / W' sa=0 sb=0 sd=0
VO_m420 m420o Vmem 0
XR_m421 m421r m421r Vdd Vdd pfet_03v3 L=2.847u W=1.355u nf=1 ad='int((nf+1)/2) * W/nf * 0.18u' as='int((nf+2)/2) * W/nf * 0.18u' pd='2*int((nf+1)/2) * (W/nf + 0.18u)' ps='2*int((nf+2)/2) * (W/nf + 0.18u)' nrd='0.18u / W' nrs='0.18u / W' sa=0 sb=0 sd=0
VR_m421 nref m421r 0
XO_m421 m421o m421r Vdd Vdd pfet_03v3 L=2.997u W=1.246u nf=1 ad='int((nf+1)/2) * W/nf * 0.18u' as='int((nf+2)/2) * W/nf * 0.18u' pd='2*int((nf+1)/2) * (W/nf + 0.18u)' ps='2*int((nf+2)/2) * (W/nf + 0.18u)' nrd='0.18u / W' nrs='0.18u / W' sa=0 sb=0 sd=0
VO_m421 m421o Vmem 0
XR_m422 m422r m422r Vdd Vdd pfet_03v3 L=0.618u W=0.995u nf=1 ad='int((nf+1)/2) * W/nf * 0.18u' as='int((nf+2)/2) * W/nf * 0.18u' pd='2*int((nf+1)/2) * (W/nf + 0.18u)' ps='2*int((nf+2)/2) * (W/nf + 0.18u)' nrd='0.18u / W' nrs='0.18u / W' sa=0 sb=0 sd=0
VR_m422 nref m422r 0
XO_m422 m422o m422r Vdd Vdd pfet_03v3 L=6.34u W=2.074u nf=1 ad='int((nf+1)/2) * W/nf * 0.18u' as='int((nf+2)/2) * W/nf * 0.18u' pd='2*int((nf+1)/2) * (W/nf + 0.18u)' ps='2*int((nf+2)/2) * (W/nf + 0.18u)' nrd='0.18u / W' nrs='0.18u / W' sa=0 sb=0 sd=0
VO_m422 m422o Vmem 0
XR_m423 m423r m423r Vdd Vdd pfet_03v3 L=1.224u W=1.211u nf=1 ad='int((nf+1)/2) * W/nf * 0.18u' as='int((nf+2)/2) * W/nf * 0.18u' pd='2*int((nf+1)/2) * (W/nf + 0.18u)' ps='2*int((nf+2)/2) * (W/nf + 0.18u)' nrd='0.18u / W' nrs='0.18u / W' sa=0 sb=0 sd=0
VR_m423 nref m423r 0
XO_m423 m423o m423r Vdd Vdd pfet_03v3 L=2.058u W=0.826u nf=1 ad='int((nf+1)/2) * W/nf * 0.18u' as='int((nf+2)/2) * W/nf * 0.18u' pd='2*int((nf+1)/2) * (W/nf + 0.18u)' ps='2*int((nf+2)/2) * (W/nf + 0.18u)' nrd='0.18u / W' nrs='0.18u / W' sa=0 sb=0 sd=0
VO_m423 m423o Vmem 0
XR_m424 m424r m424r Vdd Vdd pfet_03v3 L=0.453u W=1.815u nf=1 ad='int((nf+1)/2) * W/nf * 0.18u' as='int((nf+2)/2) * W/nf * 0.18u' pd='2*int((nf+1)/2) * (W/nf + 0.18u)' ps='2*int((nf+2)/2) * (W/nf + 0.18u)' nrd='0.18u / W' nrs='0.18u / W' sa=0 sb=0 sd=0
VR_m424 nref m424r 0
XO_m424 m424o m424r Vdd Vdd pfet_03v3 L=1.094u W=2.227u nf=1 ad='int((nf+1)/2) * W/nf * 0.18u' as='int((nf+2)/2) * W/nf * 0.18u' pd='2*int((nf+1)/2) * (W/nf + 0.18u)' ps='2*int((nf+2)/2) * (W/nf + 0.18u)' nrd='0.18u / W' nrs='0.18u / W' sa=0 sb=0 sd=0
VO_m424 m424o Vmem 0
XR_m425 m425r m425r Vdd Vdd pfet_03v3 L=0.634u W=0.764u nf=1 ad='int((nf+1)/2) * W/nf * 0.18u' as='int((nf+2)/2) * W/nf * 0.18u' pd='2*int((nf+1)/2) * (W/nf + 0.18u)' ps='2*int((nf+2)/2) * (W/nf + 0.18u)' nrd='0.18u / W' nrs='0.18u / W' sa=0 sb=0 sd=0
VR_m425 nref m425r 0
XO_m425 m425o m425r Vdd Vdd pfet_03v3 L=4.754u W=1.058u nf=1 ad='int((nf+1)/2) * W/nf * 0.18u' as='int((nf+2)/2) * W/nf * 0.18u' pd='2*int((nf+1)/2) * (W/nf + 0.18u)' ps='2*int((nf+2)/2) * (W/nf + 0.18u)' nrd='0.18u / W' nrs='0.18u / W' sa=0 sb=0 sd=0
VO_m425 m425o Vmem 0
XR_m426 m426r m426r Vdd Vdd pfet_03v3 L=0.309u W=2.277u nf=1 ad='int((nf+1)/2) * W/nf * 0.18u' as='int((nf+2)/2) * W/nf * 0.18u' pd='2*int((nf+1)/2) * (W/nf + 0.18u)' ps='2*int((nf+2)/2) * (W/nf + 0.18u)' nrd='0.18u / W' nrs='0.18u / W' sa=0 sb=0 sd=0
VR_m426 nref m426r 0
XO_m426 m426o m426r Vdd Vdd pfet_03v3 L=2.201u W=0.623u nf=1 ad='int((nf+1)/2) * W/nf * 0.18u' as='int((nf+2)/2) * W/nf * 0.18u' pd='2*int((nf+1)/2) * (W/nf + 0.18u)' ps='2*int((nf+2)/2) * (W/nf + 0.18u)' nrd='0.18u / W' nrs='0.18u / W' sa=0 sb=0 sd=0
VO_m426 m426o Vmem 0
XR_m427 m427r m427r Vdd Vdd pfet_03v3 L=1.774u W=1.65u nf=1 ad='int((nf+1)/2) * W/nf * 0.18u' as='int((nf+2)/2) * W/nf * 0.18u' pd='2*int((nf+1)/2) * (W/nf + 0.18u)' ps='2*int((nf+2)/2) * (W/nf + 0.18u)' nrd='0.18u / W' nrs='0.18u / W' sa=0 sb=0 sd=0
VR_m427 nref m427r 0
XO_m427 m427o m427r Vdd Vdd pfet_03v3 L=0.949u W=1.722u nf=1 ad='int((nf+1)/2) * W/nf * 0.18u' as='int((nf+2)/2) * W/nf * 0.18u' pd='2*int((nf+1)/2) * (W/nf + 0.18u)' ps='2*int((nf+2)/2) * (W/nf + 0.18u)' nrd='0.18u / W' nrs='0.18u / W' sa=0 sb=0 sd=0
VO_m427 m427o Vmem 0
XR_m428 m428r m428r Vdd Vdd pfet_03v3 L=1.837u W=2.259u nf=1 ad='int((nf+1)/2) * W/nf * 0.18u' as='int((nf+2)/2) * W/nf * 0.18u' pd='2*int((nf+1)/2) * (W/nf + 0.18u)' ps='2*int((nf+2)/2) * (W/nf + 0.18u)' nrd='0.18u / W' nrs='0.18u / W' sa=0 sb=0 sd=0
VR_m428 nref m428r 0
XO_m428 m428o m428r Vdd Vdd pfet_03v3 L=0.922u W=0.786u nf=1 ad='int((nf+1)/2) * W/nf * 0.18u' as='int((nf+2)/2) * W/nf * 0.18u' pd='2*int((nf+1)/2) * (W/nf + 0.18u)' ps='2*int((nf+2)/2) * (W/nf + 0.18u)' nrd='0.18u / W' nrs='0.18u / W' sa=0 sb=0 sd=0
VO_m428 m428o Vmem 0
XR_m429 m429r m429r Vdd Vdd pfet_03v3 L=0.873u W=2.839u nf=1 ad='int((nf+1)/2) * W/nf * 0.18u' as='int((nf+2)/2) * W/nf * 0.18u' pd='2*int((nf+1)/2) * (W/nf + 0.18u)' ps='2*int((nf+2)/2) * (W/nf + 0.18u)' nrd='0.18u / W' nrs='0.18u / W' sa=0 sb=0 sd=0
VR_m429 nref m429r 0
XO_m429 m429o m429r Vdd Vdd pfet_03v3 L=6.168u W=0.323u nf=1 ad='int((nf+1)/2) * W/nf * 0.18u' as='int((nf+2)/2) * W/nf * 0.18u' pd='2*int((nf+1)/2) * (W/nf + 0.18u)' ps='2*int((nf+2)/2) * (W/nf + 0.18u)' nrd='0.18u / W' nrs='0.18u / W' sa=0 sb=0 sd=0
VO_m429 m429o Vmem 0
XR_m430 m430r m430r Vdd Vdd pfet_03v3 L=2.343u W=2.125u nf=1 ad='int((nf+1)/2) * W/nf * 0.18u' as='int((nf+2)/2) * W/nf * 0.18u' pd='2*int((nf+1)/2) * (W/nf + 0.18u)' ps='2*int((nf+2)/2) * (W/nf + 0.18u)' nrd='0.18u / W' nrs='0.18u / W' sa=0 sb=0 sd=0
VR_m430 nref m430r 0
XO_m430 m430o m430r Vdd Vdd pfet_03v3 L=0.395u W=1.168u nf=1 ad='int((nf+1)/2) * W/nf * 0.18u' as='int((nf+2)/2) * W/nf * 0.18u' pd='2*int((nf+1)/2) * (W/nf + 0.18u)' ps='2*int((nf+2)/2) * (W/nf + 0.18u)' nrd='0.18u / W' nrs='0.18u / W' sa=0 sb=0 sd=0
VO_m430 m430o Vmem 0
XR_m431 m431r m431r Vdd Vdd pfet_03v3 L=1.804u W=0.873u nf=1 ad='int((nf+1)/2) * W/nf * 0.18u' as='int((nf+2)/2) * W/nf * 0.18u' pd='2*int((nf+1)/2) * (W/nf + 0.18u)' ps='2*int((nf+2)/2) * (W/nf + 0.18u)' nrd='0.18u / W' nrs='0.18u / W' sa=0 sb=0 sd=0
VR_m431 nref m431r 0
XO_m431 m431o m431r Vdd Vdd pfet_03v3 L=0.537u W=1.336u nf=1 ad='int((nf+1)/2) * W/nf * 0.18u' as='int((nf+2)/2) * W/nf * 0.18u' pd='2*int((nf+1)/2) * (W/nf + 0.18u)' ps='2*int((nf+2)/2) * (W/nf + 0.18u)' nrd='0.18u / W' nrs='0.18u / W' sa=0 sb=0 sd=0
VO_m431 m431o Vmem 0
XR_m432 m432r m432r Vdd Vdd pfet_03v3 L=3.426u W=1.187u nf=1 ad='int((nf+1)/2) * W/nf * 0.18u' as='int((nf+2)/2) * W/nf * 0.18u' pd='2*int((nf+1)/2) * (W/nf + 0.18u)' ps='2*int((nf+2)/2) * (W/nf + 0.18u)' nrd='0.18u / W' nrs='0.18u / W' sa=0 sb=0 sd=0
VR_m432 nref m432r 0
XO_m432 m432o m432r Vdd Vdd pfet_03v3 L=3.052u W=0.719u nf=1 ad='int((nf+1)/2) * W/nf * 0.18u' as='int((nf+2)/2) * W/nf * 0.18u' pd='2*int((nf+1)/2) * (W/nf + 0.18u)' ps='2*int((nf+2)/2) * (W/nf + 0.18u)' nrd='0.18u / W' nrs='0.18u / W' sa=0 sb=0 sd=0
VO_m432 m432o Vmem 0
XR_m433 m433r m433r Vdd Vdd pfet_03v3 L=0.479u W=3.051u nf=1 ad='int((nf+1)/2) * W/nf * 0.18u' as='int((nf+2)/2) * W/nf * 0.18u' pd='2*int((nf+1)/2) * (W/nf + 0.18u)' ps='2*int((nf+2)/2) * (W/nf + 0.18u)' nrd='0.18u / W' nrs='0.18u / W' sa=0 sb=0 sd=0
VR_m433 nref m433r 0
XO_m433 m433o m433r Vdd Vdd pfet_03v3 L=1.002u W=0.412u nf=1 ad='int((nf+1)/2) * W/nf * 0.18u' as='int((nf+2)/2) * W/nf * 0.18u' pd='2*int((nf+1)/2) * (W/nf + 0.18u)' ps='2*int((nf+2)/2) * (W/nf + 0.18u)' nrd='0.18u / W' nrs='0.18u / W' sa=0 sb=0 sd=0
VO_m433 m433o Vmem 0
XR_m434 m434r m434r Vdd Vdd pfet_03v3 L=2.674u W=2.56u nf=1 ad='int((nf+1)/2) * W/nf * 0.18u' as='int((nf+2)/2) * W/nf * 0.18u' pd='2*int((nf+1)/2) * (W/nf + 0.18u)' ps='2*int((nf+2)/2) * (W/nf + 0.18u)' nrd='0.18u / W' nrs='0.18u / W' sa=0 sb=0 sd=0
VR_m434 nref m434r 0
XO_m434 m434o m434r Vdd Vdd pfet_03v3 L=0.5u W=0.782u nf=1 ad='int((nf+1)/2) * W/nf * 0.18u' as='int((nf+2)/2) * W/nf * 0.18u' pd='2*int((nf+1)/2) * (W/nf + 0.18u)' ps='2*int((nf+2)/2) * (W/nf + 0.18u)' nrd='0.18u / W' nrs='0.18u / W' sa=0 sb=0 sd=0
VO_m434 m434o Vmem 0
XR_m435 m435r m435r Vdd Vdd pfet_03v3 L=0.934u W=1.494u nf=1 ad='int((nf+1)/2) * W/nf * 0.18u' as='int((nf+2)/2) * W/nf * 0.18u' pd='2*int((nf+1)/2) * (W/nf + 0.18u)' ps='2*int((nf+2)/2) * (W/nf + 0.18u)' nrd='0.18u / W' nrs='0.18u / W' sa=0 sb=0 sd=0
VR_m435 nref m435r 0
XO_m435 m435o m435r Vdd Vdd pfet_03v3 L=5.266u W=0.344u nf=1 ad='int((nf+1)/2) * W/nf * 0.18u' as='int((nf+2)/2) * W/nf * 0.18u' pd='2*int((nf+1)/2) * (W/nf + 0.18u)' ps='2*int((nf+2)/2) * (W/nf + 0.18u)' nrd='0.18u / W' nrs='0.18u / W' sa=0 sb=0 sd=0
VO_m435 m435o Vmem 0
XR_m436 m436r m436r Vdd Vdd pfet_03v3 L=2.171u W=2.277u nf=1 ad='int((nf+1)/2) * W/nf * 0.18u' as='int((nf+2)/2) * W/nf * 0.18u' pd='2*int((nf+1)/2) * (W/nf + 0.18u)' ps='2*int((nf+2)/2) * (W/nf + 0.18u)' nrd='0.18u / W' nrs='0.18u / W' sa=0 sb=0 sd=0
VR_m436 nref m436r 0
XO_m436 m436o m436r Vdd Vdd pfet_03v3 L=0.512u W=0.636u nf=1 ad='int((nf+1)/2) * W/nf * 0.18u' as='int((nf+2)/2) * W/nf * 0.18u' pd='2*int((nf+1)/2) * (W/nf + 0.18u)' ps='2*int((nf+2)/2) * (W/nf + 0.18u)' nrd='0.18u / W' nrs='0.18u / W' sa=0 sb=0 sd=0
VO_m436 m436o Vmem 0
XR_m437 m437r m437r Vdd Vdd pfet_03v3 L=0.751u W=1.225u nf=1 ad='int((nf+1)/2) * W/nf * 0.18u' as='int((nf+2)/2) * W/nf * 0.18u' pd='2*int((nf+1)/2) * (W/nf + 0.18u)' ps='2*int((nf+2)/2) * (W/nf + 0.18u)' nrd='0.18u / W' nrs='0.18u / W' sa=0 sb=0 sd=0
VR_m437 nref m437r 0
XO_m437 m437o m437r Vdd Vdd pfet_03v3 L=0.905u W=2.903u nf=1 ad='int((nf+1)/2) * W/nf * 0.18u' as='int((nf+2)/2) * W/nf * 0.18u' pd='2*int((nf+1)/2) * (W/nf + 0.18u)' ps='2*int((nf+2)/2) * (W/nf + 0.18u)' nrd='0.18u / W' nrs='0.18u / W' sa=0 sb=0 sd=0
VO_m437 m437o Vmem 0
XR_m438 m438r m438r Vdd Vdd pfet_03v3 L=2.753u W=0.508u nf=1 ad='int((nf+1)/2) * W/nf * 0.18u' as='int((nf+2)/2) * W/nf * 0.18u' pd='2*int((nf+1)/2) * (W/nf + 0.18u)' ps='2*int((nf+2)/2) * (W/nf + 0.18u)' nrd='0.18u / W' nrs='0.18u / W' sa=0 sb=0 sd=0
VR_m438 nref m438r 0
XO_m438 m438o m438r Vdd Vdd pfet_03v3 L=1.381u W=0.503u nf=1 ad='int((nf+1)/2) * W/nf * 0.18u' as='int((nf+2)/2) * W/nf * 0.18u' pd='2*int((nf+1)/2) * (W/nf + 0.18u)' ps='2*int((nf+2)/2) * (W/nf + 0.18u)' nrd='0.18u / W' nrs='0.18u / W' sa=0 sb=0 sd=0
VO_m438 m438o Vmem 0
XR_m439 m439r m439r Vdd Vdd pfet_03v3 L=3.933u W=1.194u nf=1 ad='int((nf+1)/2) * W/nf * 0.18u' as='int((nf+2)/2) * W/nf * 0.18u' pd='2*int((nf+1)/2) * (W/nf + 0.18u)' ps='2*int((nf+2)/2) * (W/nf + 0.18u)' nrd='0.18u / W' nrs='0.18u / W' sa=0 sb=0 sd=0
VR_m439 nref m439r 0
XO_m439 m439o m439r Vdd Vdd pfet_03v3 L=1.609u W=0.436u nf=1 ad='int((nf+1)/2) * W/nf * 0.18u' as='int((nf+2)/2) * W/nf * 0.18u' pd='2*int((nf+1)/2) * (W/nf + 0.18u)' ps='2*int((nf+2)/2) * (W/nf + 0.18u)' nrd='0.18u / W' nrs='0.18u / W' sa=0 sb=0 sd=0
VO_m439 m439o Vmem 0
XR_m440 m440r m440r Vdd Vdd pfet_03v3 L=1.243u W=0.62u nf=1 ad='int((nf+1)/2) * W/nf * 0.18u' as='int((nf+2)/2) * W/nf * 0.18u' pd='2*int((nf+1)/2) * (W/nf + 0.18u)' ps='2*int((nf+2)/2) * (W/nf + 0.18u)' nrd='0.18u / W' nrs='0.18u / W' sa=0 sb=0 sd=0
VR_m440 nref m440r 0
XO_m440 m440o m440r Vdd Vdd pfet_03v3 L=2.419u W=1.097u nf=1 ad='int((nf+1)/2) * W/nf * 0.18u' as='int((nf+2)/2) * W/nf * 0.18u' pd='2*int((nf+1)/2) * (W/nf + 0.18u)' ps='2*int((nf+2)/2) * (W/nf + 0.18u)' nrd='0.18u / W' nrs='0.18u / W' sa=0 sb=0 sd=0
VO_m440 m440o Vmem 0
XR_m441 m441r m441r Vdd Vdd pfet_03v3 L=0.412u W=0.341u nf=1 ad='int((nf+1)/2) * W/nf * 0.18u' as='int((nf+2)/2) * W/nf * 0.18u' pd='2*int((nf+1)/2) * (W/nf + 0.18u)' ps='2*int((nf+2)/2) * (W/nf + 0.18u)' nrd='0.18u / W' nrs='0.18u / W' sa=0 sb=0 sd=0
VR_m441 nref m441r 0
XO_m441 m441o m441r Vdd Vdd pfet_03v3 L=1.279u W=1.841u nf=1 ad='int((nf+1)/2) * W/nf * 0.18u' as='int((nf+2)/2) * W/nf * 0.18u' pd='2*int((nf+1)/2) * (W/nf + 0.18u)' ps='2*int((nf+2)/2) * (W/nf + 0.18u)' nrd='0.18u / W' nrs='0.18u / W' sa=0 sb=0 sd=0
VO_m441 m441o Vmem 0
XR_m442 m442r m442r Vdd Vdd pfet_03v3 L=0.38u W=0.396u nf=1 ad='int((nf+1)/2) * W/nf * 0.18u' as='int((nf+2)/2) * W/nf * 0.18u' pd='2*int((nf+1)/2) * (W/nf + 0.18u)' ps='2*int((nf+2)/2) * (W/nf + 0.18u)' nrd='0.18u / W' nrs='0.18u / W' sa=0 sb=0 sd=0
VR_m442 nref m442r 0
XO_m442 m442o m442r Vdd Vdd pfet_03v3 L=6.578u W=2.484u nf=1 ad='int((nf+1)/2) * W/nf * 0.18u' as='int((nf+2)/2) * W/nf * 0.18u' pd='2*int((nf+1)/2) * (W/nf + 0.18u)' ps='2*int((nf+2)/2) * (W/nf + 0.18u)' nrd='0.18u / W' nrs='0.18u / W' sa=0 sb=0 sd=0
VO_m442 m442o Vmem 0
XR_m443 m443r m443r Vdd Vdd pfet_03v3 L=0.438u W=0.427u nf=1 ad='int((nf+1)/2) * W/nf * 0.18u' as='int((nf+2)/2) * W/nf * 0.18u' pd='2*int((nf+1)/2) * (W/nf + 0.18u)' ps='2*int((nf+2)/2) * (W/nf + 0.18u)' nrd='0.18u / W' nrs='0.18u / W' sa=0 sb=0 sd=0
VR_m443 nref m443r 0
XO_m443 m443o m443r Vdd Vdd pfet_03v3 L=0.737u W=0.235u nf=1 ad='int((nf+1)/2) * W/nf * 0.18u' as='int((nf+2)/2) * W/nf * 0.18u' pd='2*int((nf+1)/2) * (W/nf + 0.18u)' ps='2*int((nf+2)/2) * (W/nf + 0.18u)' nrd='0.18u / W' nrs='0.18u / W' sa=0 sb=0 sd=0
VO_m443 m443o Vmem 0
XR_m444 m444r m444r Vdd Vdd pfet_03v3 L=0.411u W=1.824u nf=1 ad='int((nf+1)/2) * W/nf * 0.18u' as='int((nf+2)/2) * W/nf * 0.18u' pd='2*int((nf+1)/2) * (W/nf + 0.18u)' ps='2*int((nf+2)/2) * (W/nf + 0.18u)' nrd='0.18u / W' nrs='0.18u / W' sa=0 sb=0 sd=0
VR_m444 nref m444r 0
XO_m444 m444o m444r Vdd Vdd pfet_03v3 L=0.571u W=1.47u nf=1 ad='int((nf+1)/2) * W/nf * 0.18u' as='int((nf+2)/2) * W/nf * 0.18u' pd='2*int((nf+1)/2) * (W/nf + 0.18u)' ps='2*int((nf+2)/2) * (W/nf + 0.18u)' nrd='0.18u / W' nrs='0.18u / W' sa=0 sb=0 sd=0
VO_m444 m444o Vmem 0
XR_m445 m445r m445r Vdd Vdd pfet_03v3 L=1.276u W=2.454u nf=1 ad='int((nf+1)/2) * W/nf * 0.18u' as='int((nf+2)/2) * W/nf * 0.18u' pd='2*int((nf+1)/2) * (W/nf + 0.18u)' ps='2*int((nf+2)/2) * (W/nf + 0.18u)' nrd='0.18u / W' nrs='0.18u / W' sa=0 sb=0 sd=0
VR_m445 nref m445r 0
XO_m445 m445o m445r Vdd Vdd pfet_03v3 L=1.209u W=0.221u nf=1 ad='int((nf+1)/2) * W/nf * 0.18u' as='int((nf+2)/2) * W/nf * 0.18u' pd='2*int((nf+1)/2) * (W/nf + 0.18u)' ps='2*int((nf+2)/2) * (W/nf + 0.18u)' nrd='0.18u / W' nrs='0.18u / W' sa=0 sb=0 sd=0
VO_m445 m445o Vmem 0
XR_m446 m446r m446r Vdd Vdd pfet_03v3 L=2.246u W=3.046u nf=1 ad='int((nf+1)/2) * W/nf * 0.18u' as='int((nf+2)/2) * W/nf * 0.18u' pd='2*int((nf+1)/2) * (W/nf + 0.18u)' ps='2*int((nf+2)/2) * (W/nf + 0.18u)' nrd='0.18u / W' nrs='0.18u / W' sa=0 sb=0 sd=0
VR_m446 nref m446r 0
XO_m446 m446o m446r Vdd Vdd pfet_03v3 L=7.231u W=1.874u nf=1 ad='int((nf+1)/2) * W/nf * 0.18u' as='int((nf+2)/2) * W/nf * 0.18u' pd='2*int((nf+1)/2) * (W/nf + 0.18u)' ps='2*int((nf+2)/2) * (W/nf + 0.18u)' nrd='0.18u / W' nrs='0.18u / W' sa=0 sb=0 sd=0
VO_m446 m446o Vmem 0
XR_m447 m447r m447r Vdd Vdd pfet_03v3 L=1.297u W=1.282u nf=1 ad='int((nf+1)/2) * W/nf * 0.18u' as='int((nf+2)/2) * W/nf * 0.18u' pd='2*int((nf+1)/2) * (W/nf + 0.18u)' ps='2*int((nf+2)/2) * (W/nf + 0.18u)' nrd='0.18u / W' nrs='0.18u / W' sa=0 sb=0 sd=0
VR_m447 nref m447r 0
XO_m447 m447o m447r Vdd Vdd pfet_03v3 L=1.202u W=1.565u nf=1 ad='int((nf+1)/2) * W/nf * 0.18u' as='int((nf+2)/2) * W/nf * 0.18u' pd='2*int((nf+1)/2) * (W/nf + 0.18u)' ps='2*int((nf+2)/2) * (W/nf + 0.18u)' nrd='0.18u / W' nrs='0.18u / W' sa=0 sb=0 sd=0
VO_m447 m447o Vmem 0
XR_m448 m448r m448r Vdd Vdd pfet_03v3 L=0.439u W=0.233u nf=1 ad='int((nf+1)/2) * W/nf * 0.18u' as='int((nf+2)/2) * W/nf * 0.18u' pd='2*int((nf+1)/2) * (W/nf + 0.18u)' ps='2*int((nf+2)/2) * (W/nf + 0.18u)' nrd='0.18u / W' nrs='0.18u / W' sa=0 sb=0 sd=0
VR_m448 nref m448r 0
XO_m448 m448o m448r Vdd Vdd pfet_03v3 L=0.47u W=1.902u nf=1 ad='int((nf+1)/2) * W/nf * 0.18u' as='int((nf+2)/2) * W/nf * 0.18u' pd='2*int((nf+1)/2) * (W/nf + 0.18u)' ps='2*int((nf+2)/2) * (W/nf + 0.18u)' nrd='0.18u / W' nrs='0.18u / W' sa=0 sb=0 sd=0
VO_m448 m448o Vmem 0
XR_m449 m449r m449r Vdd Vdd pfet_03v3 L=3.619u W=0.24u nf=1 ad='int((nf+1)/2) * W/nf * 0.18u' as='int((nf+2)/2) * W/nf * 0.18u' pd='2*int((nf+1)/2) * (W/nf + 0.18u)' ps='2*int((nf+2)/2) * (W/nf + 0.18u)' nrd='0.18u / W' nrs='0.18u / W' sa=0 sb=0 sd=0
VR_m449 nref m449r 0
XO_m449 m449o m449r Vdd Vdd pfet_03v3 L=7.489u W=0.341u nf=1 ad='int((nf+1)/2) * W/nf * 0.18u' as='int((nf+2)/2) * W/nf * 0.18u' pd='2*int((nf+1)/2) * (W/nf + 0.18u)' ps='2*int((nf+2)/2) * (W/nf + 0.18u)' nrd='0.18u / W' nrs='0.18u / W' sa=0 sb=0 sd=0
VO_m449 m449o Vmem 0
XR_m450 m450r m450r Vdd Vdd pfet_03v3 L=1.258u W=1.361u nf=1 ad='int((nf+1)/2) * W/nf * 0.18u' as='int((nf+2)/2) * W/nf * 0.18u' pd='2*int((nf+1)/2) * (W/nf + 0.18u)' ps='2*int((nf+2)/2) * (W/nf + 0.18u)' nrd='0.18u / W' nrs='0.18u / W' sa=0 sb=0 sd=0
VR_m450 nref m450r 0
XO_m450 m450o m450r Vdd Vdd pfet_03v3 L=0.913u W=0.38u nf=1 ad='int((nf+1)/2) * W/nf * 0.18u' as='int((nf+2)/2) * W/nf * 0.18u' pd='2*int((nf+1)/2) * (W/nf + 0.18u)' ps='2*int((nf+2)/2) * (W/nf + 0.18u)' nrd='0.18u / W' nrs='0.18u / W' sa=0 sb=0 sd=0
VO_m450 m450o Vmem 0
XR_m451 m451r m451r Vdd Vdd pfet_03v3 L=0.473u W=3.302u nf=1 ad='int((nf+1)/2) * W/nf * 0.18u' as='int((nf+2)/2) * W/nf * 0.18u' pd='2*int((nf+1)/2) * (W/nf + 0.18u)' ps='2*int((nf+2)/2) * (W/nf + 0.18u)' nrd='0.18u / W' nrs='0.18u / W' sa=0 sb=0 sd=0
VR_m451 nref m451r 0
XO_m451 m451o m451r Vdd Vdd pfet_03v3 L=0.794u W=3.18u nf=1 ad='int((nf+1)/2) * W/nf * 0.18u' as='int((nf+2)/2) * W/nf * 0.18u' pd='2*int((nf+1)/2) * (W/nf + 0.18u)' ps='2*int((nf+2)/2) * (W/nf + 0.18u)' nrd='0.18u / W' nrs='0.18u / W' sa=0 sb=0 sd=0
VO_m451 m451o Vmem 0
XR_m452 m452r m452r Vdd Vdd pfet_03v3 L=2.588u W=0.616u nf=1 ad='int((nf+1)/2) * W/nf * 0.18u' as='int((nf+2)/2) * W/nf * 0.18u' pd='2*int((nf+1)/2) * (W/nf + 0.18u)' ps='2*int((nf+2)/2) * (W/nf + 0.18u)' nrd='0.18u / W' nrs='0.18u / W' sa=0 sb=0 sd=0
VR_m452 nref m452r 0
XO_m452 m452o m452r Vdd Vdd pfet_03v3 L=0.416u W=0.494u nf=1 ad='int((nf+1)/2) * W/nf * 0.18u' as='int((nf+2)/2) * W/nf * 0.18u' pd='2*int((nf+1)/2) * (W/nf + 0.18u)' ps='2*int((nf+2)/2) * (W/nf + 0.18u)' nrd='0.18u / W' nrs='0.18u / W' sa=0 sb=0 sd=0
VO_m452 m452o Vmem 0
XR_m453 m453r m453r Vdd Vdd pfet_03v3 L=1.325u W=1.946u nf=1 ad='int((nf+1)/2) * W/nf * 0.18u' as='int((nf+2)/2) * W/nf * 0.18u' pd='2*int((nf+1)/2) * (W/nf + 0.18u)' ps='2*int((nf+2)/2) * (W/nf + 0.18u)' nrd='0.18u / W' nrs='0.18u / W' sa=0 sb=0 sd=0
VR_m453 nref m453r 0
XO_m453 m453o m453r Vdd Vdd pfet_03v3 L=0.624u W=0.785u nf=1 ad='int((nf+1)/2) * W/nf * 0.18u' as='int((nf+2)/2) * W/nf * 0.18u' pd='2*int((nf+1)/2) * (W/nf + 0.18u)' ps='2*int((nf+2)/2) * (W/nf + 0.18u)' nrd='0.18u / W' nrs='0.18u / W' sa=0 sb=0 sd=0
VO_m453 m453o Vmem 0
XR_m454 m454r m454r Vdd Vdd pfet_03v3 L=0.786u W=2.788u nf=1 ad='int((nf+1)/2) * W/nf * 0.18u' as='int((nf+2)/2) * W/nf * 0.18u' pd='2*int((nf+1)/2) * (W/nf + 0.18u)' ps='2*int((nf+2)/2) * (W/nf + 0.18u)' nrd='0.18u / W' nrs='0.18u / W' sa=0 sb=0 sd=0
VR_m454 nref m454r 0
XO_m454 m454o m454r Vdd Vdd pfet_03v3 L=1.137u W=1.035u nf=1 ad='int((nf+1)/2) * W/nf * 0.18u' as='int((nf+2)/2) * W/nf * 0.18u' pd='2*int((nf+1)/2) * (W/nf + 0.18u)' ps='2*int((nf+2)/2) * (W/nf + 0.18u)' nrd='0.18u / W' nrs='0.18u / W' sa=0 sb=0 sd=0
VO_m454 m454o Vmem 0
XR_m455 m455r m455r Vdd Vdd pfet_03v3 L=1.778u W=0.945u nf=1 ad='int((nf+1)/2) * W/nf * 0.18u' as='int((nf+2)/2) * W/nf * 0.18u' pd='2*int((nf+1)/2) * (W/nf + 0.18u)' ps='2*int((nf+2)/2) * (W/nf + 0.18u)' nrd='0.18u / W' nrs='0.18u / W' sa=0 sb=0 sd=0
VR_m455 nref m455r 0
XO_m455 m455o m455r Vdd Vdd pfet_03v3 L=4.233u W=3.989u nf=1 ad='int((nf+1)/2) * W/nf * 0.18u' as='int((nf+2)/2) * W/nf * 0.18u' pd='2*int((nf+1)/2) * (W/nf + 0.18u)' ps='2*int((nf+2)/2) * (W/nf + 0.18u)' nrd='0.18u / W' nrs='0.18u / W' sa=0 sb=0 sd=0
VO_m455 m455o Vmem 0
XR_m456 m456r m456r Vdd Vdd pfet_03v3 L=2.844u W=3.619u nf=1 ad='int((nf+1)/2) * W/nf * 0.18u' as='int((nf+2)/2) * W/nf * 0.18u' pd='2*int((nf+1)/2) * (W/nf + 0.18u)' ps='2*int((nf+2)/2) * (W/nf + 0.18u)' nrd='0.18u / W' nrs='0.18u / W' sa=0 sb=0 sd=0
VR_m456 nref m456r 0
XO_m456 m456o m456r Vdd Vdd pfet_03v3 L=0.802u W=0.464u nf=1 ad='int((nf+1)/2) * W/nf * 0.18u' as='int((nf+2)/2) * W/nf * 0.18u' pd='2*int((nf+1)/2) * (W/nf + 0.18u)' ps='2*int((nf+2)/2) * (W/nf + 0.18u)' nrd='0.18u / W' nrs='0.18u / W' sa=0 sb=0 sd=0
VO_m456 m456o Vmem 0
XR_m457 m457r m457r Vdd Vdd pfet_03v3 L=0.623u W=1.612u nf=1 ad='int((nf+1)/2) * W/nf * 0.18u' as='int((nf+2)/2) * W/nf * 0.18u' pd='2*int((nf+1)/2) * (W/nf + 0.18u)' ps='2*int((nf+2)/2) * (W/nf + 0.18u)' nrd='0.18u / W' nrs='0.18u / W' sa=0 sb=0 sd=0
VR_m457 nref m457r 0
XO_m457 m457o m457r Vdd Vdd pfet_03v3 L=2.257u W=2.702u nf=1 ad='int((nf+1)/2) * W/nf * 0.18u' as='int((nf+2)/2) * W/nf * 0.18u' pd='2*int((nf+1)/2) * (W/nf + 0.18u)' ps='2*int((nf+2)/2) * (W/nf + 0.18u)' nrd='0.18u / W' nrs='0.18u / W' sa=0 sb=0 sd=0
VO_m457 m457o Vmem 0
XR_m458 m458r m458r Vdd Vdd pfet_03v3 L=3.388u W=0.563u nf=1 ad='int((nf+1)/2) * W/nf * 0.18u' as='int((nf+2)/2) * W/nf * 0.18u' pd='2*int((nf+1)/2) * (W/nf + 0.18u)' ps='2*int((nf+2)/2) * (W/nf + 0.18u)' nrd='0.18u / W' nrs='0.18u / W' sa=0 sb=0 sd=0
VR_m458 nref m458r 0
XO_m458 m458o m458r Vdd Vdd pfet_03v3 L=4.864u W=0.436u nf=1 ad='int((nf+1)/2) * W/nf * 0.18u' as='int((nf+2)/2) * W/nf * 0.18u' pd='2*int((nf+1)/2) * (W/nf + 0.18u)' ps='2*int((nf+2)/2) * (W/nf + 0.18u)' nrd='0.18u / W' nrs='0.18u / W' sa=0 sb=0 sd=0
VO_m458 m458o Vmem 0
XR_m459 m459r m459r Vdd Vdd pfet_03v3 L=3.943u W=0.437u nf=1 ad='int((nf+1)/2) * W/nf * 0.18u' as='int((nf+2)/2) * W/nf * 0.18u' pd='2*int((nf+1)/2) * (W/nf + 0.18u)' ps='2*int((nf+2)/2) * (W/nf + 0.18u)' nrd='0.18u / W' nrs='0.18u / W' sa=0 sb=0 sd=0
VR_m459 nref m459r 0
XO_m459 m459o m459r Vdd Vdd pfet_03v3 L=2.937u W=0.449u nf=1 ad='int((nf+1)/2) * W/nf * 0.18u' as='int((nf+2)/2) * W/nf * 0.18u' pd='2*int((nf+1)/2) * (W/nf + 0.18u)' ps='2*int((nf+2)/2) * (W/nf + 0.18u)' nrd='0.18u / W' nrs='0.18u / W' sa=0 sb=0 sd=0
VO_m459 m459o Vmem 0
XR_m460 m460r m460r Vdd Vdd pfet_03v3 L=1.043u W=1.052u nf=1 ad='int((nf+1)/2) * W/nf * 0.18u' as='int((nf+2)/2) * W/nf * 0.18u' pd='2*int((nf+1)/2) * (W/nf + 0.18u)' ps='2*int((nf+2)/2) * (W/nf + 0.18u)' nrd='0.18u / W' nrs='0.18u / W' sa=0 sb=0 sd=0
VR_m460 nref m460r 0
XO_m460 m460o m460r Vdd Vdd pfet_03v3 L=3.016u W=0.229u nf=1 ad='int((nf+1)/2) * W/nf * 0.18u' as='int((nf+2)/2) * W/nf * 0.18u' pd='2*int((nf+1)/2) * (W/nf + 0.18u)' ps='2*int((nf+2)/2) * (W/nf + 0.18u)' nrd='0.18u / W' nrs='0.18u / W' sa=0 sb=0 sd=0
VO_m460 m460o Vmem 0
XR_m461 m461r m461r Vdd Vdd pfet_03v3 L=2.519u W=1.918u nf=1 ad='int((nf+1)/2) * W/nf * 0.18u' as='int((nf+2)/2) * W/nf * 0.18u' pd='2*int((nf+1)/2) * (W/nf + 0.18u)' ps='2*int((nf+2)/2) * (W/nf + 0.18u)' nrd='0.18u / W' nrs='0.18u / W' sa=0 sb=0 sd=0
VR_m461 nref m461r 0
XO_m461 m461o m461r Vdd Vdd pfet_03v3 L=5.078u W=2.58u nf=1 ad='int((nf+1)/2) * W/nf * 0.18u' as='int((nf+2)/2) * W/nf * 0.18u' pd='2*int((nf+1)/2) * (W/nf + 0.18u)' ps='2*int((nf+2)/2) * (W/nf + 0.18u)' nrd='0.18u / W' nrs='0.18u / W' sa=0 sb=0 sd=0
VO_m461 m461o Vmem 0
XR_m462 m462r m462r Vdd Vdd pfet_03v3 L=2.017u W=0.305u nf=1 ad='int((nf+1)/2) * W/nf * 0.18u' as='int((nf+2)/2) * W/nf * 0.18u' pd='2*int((nf+1)/2) * (W/nf + 0.18u)' ps='2*int((nf+2)/2) * (W/nf + 0.18u)' nrd='0.18u / W' nrs='0.18u / W' sa=0 sb=0 sd=0
VR_m462 nref m462r 0
XO_m462 m462o m462r Vdd Vdd pfet_03v3 L=3.729u W=0.282u nf=1 ad='int((nf+1)/2) * W/nf * 0.18u' as='int((nf+2)/2) * W/nf * 0.18u' pd='2*int((nf+1)/2) * (W/nf + 0.18u)' ps='2*int((nf+2)/2) * (W/nf + 0.18u)' nrd='0.18u / W' nrs='0.18u / W' sa=0 sb=0 sd=0
VO_m462 m462o Vmem 0
XR_m463 m463r m463r Vdd Vdd pfet_03v3 L=0.299u W=0.475u nf=1 ad='int((nf+1)/2) * W/nf * 0.18u' as='int((nf+2)/2) * W/nf * 0.18u' pd='2*int((nf+1)/2) * (W/nf + 0.18u)' ps='2*int((nf+2)/2) * (W/nf + 0.18u)' nrd='0.18u / W' nrs='0.18u / W' sa=0 sb=0 sd=0
VR_m463 nref m463r 0
XO_m463 m463o m463r Vdd Vdd pfet_03v3 L=0.503u W=3.606u nf=1 ad='int((nf+1)/2) * W/nf * 0.18u' as='int((nf+2)/2) * W/nf * 0.18u' pd='2*int((nf+1)/2) * (W/nf + 0.18u)' ps='2*int((nf+2)/2) * (W/nf + 0.18u)' nrd='0.18u / W' nrs='0.18u / W' sa=0 sb=0 sd=0
VO_m463 m463o Vmem 0
XR_m464 m464r m464r Vdd Vdd pfet_03v3 L=0.445u W=3.353u nf=1 ad='int((nf+1)/2) * W/nf * 0.18u' as='int((nf+2)/2) * W/nf * 0.18u' pd='2*int((nf+1)/2) * (W/nf + 0.18u)' ps='2*int((nf+2)/2) * (W/nf + 0.18u)' nrd='0.18u / W' nrs='0.18u / W' sa=0 sb=0 sd=0
VR_m464 nref m464r 0
XO_m464 m464o m464r Vdd Vdd pfet_03v3 L=7.04u W=0.324u nf=1 ad='int((nf+1)/2) * W/nf * 0.18u' as='int((nf+2)/2) * W/nf * 0.18u' pd='2*int((nf+1)/2) * (W/nf + 0.18u)' ps='2*int((nf+2)/2) * (W/nf + 0.18u)' nrd='0.18u / W' nrs='0.18u / W' sa=0 sb=0 sd=0
VO_m464 m464o Vmem 0
XR_m465 m465r m465r Vdd Vdd pfet_03v3 L=0.419u W=1.249u nf=1 ad='int((nf+1)/2) * W/nf * 0.18u' as='int((nf+2)/2) * W/nf * 0.18u' pd='2*int((nf+1)/2) * (W/nf + 0.18u)' ps='2*int((nf+2)/2) * (W/nf + 0.18u)' nrd='0.18u / W' nrs='0.18u / W' sa=0 sb=0 sd=0
VR_m465 nref m465r 0
XO_m465 m465o m465r Vdd Vdd pfet_03v3 L=0.563u W=0.345u nf=1 ad='int((nf+1)/2) * W/nf * 0.18u' as='int((nf+2)/2) * W/nf * 0.18u' pd='2*int((nf+1)/2) * (W/nf + 0.18u)' ps='2*int((nf+2)/2) * (W/nf + 0.18u)' nrd='0.18u / W' nrs='0.18u / W' sa=0 sb=0 sd=0
VO_m465 m465o Vmem 0
XR_m466 m466r m466r Vdd Vdd pfet_03v3 L=3.715u W=1.127u nf=1 ad='int((nf+1)/2) * W/nf * 0.18u' as='int((nf+2)/2) * W/nf * 0.18u' pd='2*int((nf+1)/2) * (W/nf + 0.18u)' ps='2*int((nf+2)/2) * (W/nf + 0.18u)' nrd='0.18u / W' nrs='0.18u / W' sa=0 sb=0 sd=0
VR_m466 nref m466r 0
XO_m466 m466o m466r Vdd Vdd pfet_03v3 L=0.496u W=1.616u nf=1 ad='int((nf+1)/2) * W/nf * 0.18u' as='int((nf+2)/2) * W/nf * 0.18u' pd='2*int((nf+1)/2) * (W/nf + 0.18u)' ps='2*int((nf+2)/2) * (W/nf + 0.18u)' nrd='0.18u / W' nrs='0.18u / W' sa=0 sb=0 sd=0
VO_m466 m466o Vmem 0
XR_m467 m467r m467r Vdd Vdd pfet_03v3 L=1.016u W=0.42u nf=1 ad='int((nf+1)/2) * W/nf * 0.18u' as='int((nf+2)/2) * W/nf * 0.18u' pd='2*int((nf+1)/2) * (W/nf + 0.18u)' ps='2*int((nf+2)/2) * (W/nf + 0.18u)' nrd='0.18u / W' nrs='0.18u / W' sa=0 sb=0 sd=0
VR_m467 nref m467r 0
XO_m467 m467o m467r Vdd Vdd pfet_03v3 L=0.984u W=2.88u nf=1 ad='int((nf+1)/2) * W/nf * 0.18u' as='int((nf+2)/2) * W/nf * 0.18u' pd='2*int((nf+1)/2) * (W/nf + 0.18u)' ps='2*int((nf+2)/2) * (W/nf + 0.18u)' nrd='0.18u / W' nrs='0.18u / W' sa=0 sb=0 sd=0
VO_m467 m467o Vmem 0
XR_m468 m468r m468r Vdd Vdd pfet_03v3 L=2.247u W=0.235u nf=1 ad='int((nf+1)/2) * W/nf * 0.18u' as='int((nf+2)/2) * W/nf * 0.18u' pd='2*int((nf+1)/2) * (W/nf + 0.18u)' ps='2*int((nf+2)/2) * (W/nf + 0.18u)' nrd='0.18u / W' nrs='0.18u / W' sa=0 sb=0 sd=0
VR_m468 nref m468r 0
XO_m468 m468o m468r Vdd Vdd pfet_03v3 L=1.066u W=0.834u nf=1 ad='int((nf+1)/2) * W/nf * 0.18u' as='int((nf+2)/2) * W/nf * 0.18u' pd='2*int((nf+1)/2) * (W/nf + 0.18u)' ps='2*int((nf+2)/2) * (W/nf + 0.18u)' nrd='0.18u / W' nrs='0.18u / W' sa=0 sb=0 sd=0
VO_m468 m468o Vmem 0
XR_m469 m469r m469r Vdd Vdd pfet_03v3 L=0.34u W=2.452u nf=1 ad='int((nf+1)/2) * W/nf * 0.18u' as='int((nf+2)/2) * W/nf * 0.18u' pd='2*int((nf+1)/2) * (W/nf + 0.18u)' ps='2*int((nf+2)/2) * (W/nf + 0.18u)' nrd='0.18u / W' nrs='0.18u / W' sa=0 sb=0 sd=0
VR_m469 nref m469r 0
XO_m469 m469o m469r Vdd Vdd pfet_03v3 L=0.873u W=0.818u nf=1 ad='int((nf+1)/2) * W/nf * 0.18u' as='int((nf+2)/2) * W/nf * 0.18u' pd='2*int((nf+1)/2) * (W/nf + 0.18u)' ps='2*int((nf+2)/2) * (W/nf + 0.18u)' nrd='0.18u / W' nrs='0.18u / W' sa=0 sb=0 sd=0
VO_m469 m469o Vmem 0
XR_m470 m470r m470r Vdd Vdd pfet_03v3 L=0.76u W=0.761u nf=1 ad='int((nf+1)/2) * W/nf * 0.18u' as='int((nf+2)/2) * W/nf * 0.18u' pd='2*int((nf+1)/2) * (W/nf + 0.18u)' ps='2*int((nf+2)/2) * (W/nf + 0.18u)' nrd='0.18u / W' nrs='0.18u / W' sa=0 sb=0 sd=0
VR_m470 nref m470r 0
XO_m470 m470o m470r Vdd Vdd pfet_03v3 L=4.307u W=0.608u nf=1 ad='int((nf+1)/2) * W/nf * 0.18u' as='int((nf+2)/2) * W/nf * 0.18u' pd='2*int((nf+1)/2) * (W/nf + 0.18u)' ps='2*int((nf+2)/2) * (W/nf + 0.18u)' nrd='0.18u / W' nrs='0.18u / W' sa=0 sb=0 sd=0
VO_m470 m470o Vmem 0
XR_m471 m471r m471r Vdd Vdd pfet_03v3 L=0.973u W=0.245u nf=1 ad='int((nf+1)/2) * W/nf * 0.18u' as='int((nf+2)/2) * W/nf * 0.18u' pd='2*int((nf+1)/2) * (W/nf + 0.18u)' ps='2*int((nf+2)/2) * (W/nf + 0.18u)' nrd='0.18u / W' nrs='0.18u / W' sa=0 sb=0 sd=0
VR_m471 nref m471r 0
XO_m471 m471o m471r Vdd Vdd pfet_03v3 L=4.715u W=1.069u nf=1 ad='int((nf+1)/2) * W/nf * 0.18u' as='int((nf+2)/2) * W/nf * 0.18u' pd='2*int((nf+1)/2) * (W/nf + 0.18u)' ps='2*int((nf+2)/2) * (W/nf + 0.18u)' nrd='0.18u / W' nrs='0.18u / W' sa=0 sb=0 sd=0
VO_m471 m471o Vmem 0
XR_m472 m472r m472r Vdd Vdd pfet_03v3 L=0.322u W=0.31u nf=1 ad='int((nf+1)/2) * W/nf * 0.18u' as='int((nf+2)/2) * W/nf * 0.18u' pd='2*int((nf+1)/2) * (W/nf + 0.18u)' ps='2*int((nf+2)/2) * (W/nf + 0.18u)' nrd='0.18u / W' nrs='0.18u / W' sa=0 sb=0 sd=0
VR_m472 nref m472r 0
XO_m472 m472o m472r Vdd Vdd pfet_03v3 L=0.805u W=2.955u nf=1 ad='int((nf+1)/2) * W/nf * 0.18u' as='int((nf+2)/2) * W/nf * 0.18u' pd='2*int((nf+1)/2) * (W/nf + 0.18u)' ps='2*int((nf+2)/2) * (W/nf + 0.18u)' nrd='0.18u / W' nrs='0.18u / W' sa=0 sb=0 sd=0
VO_m472 m472o Vmem 0
XR_m473 m473r m473r Vdd Vdd pfet_03v3 L=0.895u W=1.841u nf=1 ad='int((nf+1)/2) * W/nf * 0.18u' as='int((nf+2)/2) * W/nf * 0.18u' pd='2*int((nf+1)/2) * (W/nf + 0.18u)' ps='2*int((nf+2)/2) * (W/nf + 0.18u)' nrd='0.18u / W' nrs='0.18u / W' sa=0 sb=0 sd=0
VR_m473 nref m473r 0
XO_m473 m473o m473r Vdd Vdd pfet_03v3 L=0.318u W=2.462u nf=1 ad='int((nf+1)/2) * W/nf * 0.18u' as='int((nf+2)/2) * W/nf * 0.18u' pd='2*int((nf+1)/2) * (W/nf + 0.18u)' ps='2*int((nf+2)/2) * (W/nf + 0.18u)' nrd='0.18u / W' nrs='0.18u / W' sa=0 sb=0 sd=0
VO_m473 m473o Vmem 0
XR_m474 m474r m474r Vdd Vdd pfet_03v3 L=0.487u W=0.285u nf=1 ad='int((nf+1)/2) * W/nf * 0.18u' as='int((nf+2)/2) * W/nf * 0.18u' pd='2*int((nf+1)/2) * (W/nf + 0.18u)' ps='2*int((nf+2)/2) * (W/nf + 0.18u)' nrd='0.18u / W' nrs='0.18u / W' sa=0 sb=0 sd=0
VR_m474 nref m474r 0
XO_m474 m474o m474r Vdd Vdd pfet_03v3 L=5.674u W=0.73u nf=1 ad='int((nf+1)/2) * W/nf * 0.18u' as='int((nf+2)/2) * W/nf * 0.18u' pd='2*int((nf+1)/2) * (W/nf + 0.18u)' ps='2*int((nf+2)/2) * (W/nf + 0.18u)' nrd='0.18u / W' nrs='0.18u / W' sa=0 sb=0 sd=0
VO_m474 m474o Vmem 0
XR_m475 m475r m475r Vdd Vdd pfet_03v3 L=3.109u W=0.697u nf=1 ad='int((nf+1)/2) * W/nf * 0.18u' as='int((nf+2)/2) * W/nf * 0.18u' pd='2*int((nf+1)/2) * (W/nf + 0.18u)' ps='2*int((nf+2)/2) * (W/nf + 0.18u)' nrd='0.18u / W' nrs='0.18u / W' sa=0 sb=0 sd=0
VR_m475 nref m475r 0
XO_m475 m475o m475r Vdd Vdd pfet_03v3 L=5.166u W=0.355u nf=1 ad='int((nf+1)/2) * W/nf * 0.18u' as='int((nf+2)/2) * W/nf * 0.18u' pd='2*int((nf+1)/2) * (W/nf + 0.18u)' ps='2*int((nf+2)/2) * (W/nf + 0.18u)' nrd='0.18u / W' nrs='0.18u / W' sa=0 sb=0 sd=0
VO_m475 m475o Vmem 0
XR_m476 m476r m476r Vdd Vdd pfet_03v3 L=0.658u W=3.885u nf=1 ad='int((nf+1)/2) * W/nf * 0.18u' as='int((nf+2)/2) * W/nf * 0.18u' pd='2*int((nf+1)/2) * (W/nf + 0.18u)' ps='2*int((nf+2)/2) * (W/nf + 0.18u)' nrd='0.18u / W' nrs='0.18u / W' sa=0 sb=0 sd=0
VR_m476 nref m476r 0
XO_m476 m476o m476r Vdd Vdd pfet_03v3 L=0.672u W=0.989u nf=1 ad='int((nf+1)/2) * W/nf * 0.18u' as='int((nf+2)/2) * W/nf * 0.18u' pd='2*int((nf+1)/2) * (W/nf + 0.18u)' ps='2*int((nf+2)/2) * (W/nf + 0.18u)' nrd='0.18u / W' nrs='0.18u / W' sa=0 sb=0 sd=0
VO_m476 m476o Vmem 0
XR_m477 m477r m477r Vdd Vdd pfet_03v3 L=0.765u W=0.228u nf=1 ad='int((nf+1)/2) * W/nf * 0.18u' as='int((nf+2)/2) * W/nf * 0.18u' pd='2*int((nf+1)/2) * (W/nf + 0.18u)' ps='2*int((nf+2)/2) * (W/nf + 0.18u)' nrd='0.18u / W' nrs='0.18u / W' sa=0 sb=0 sd=0
VR_m477 nref m477r 0
XO_m477 m477o m477r Vdd Vdd pfet_03v3 L=5.124u W=0.8u nf=1 ad='int((nf+1)/2) * W/nf * 0.18u' as='int((nf+2)/2) * W/nf * 0.18u' pd='2*int((nf+1)/2) * (W/nf + 0.18u)' ps='2*int((nf+2)/2) * (W/nf + 0.18u)' nrd='0.18u / W' nrs='0.18u / W' sa=0 sb=0 sd=0
VO_m477 m477o Vmem 0
XR_m478 m478r m478r Vdd Vdd pfet_03v3 L=0.711u W=0.637u nf=1 ad='int((nf+1)/2) * W/nf * 0.18u' as='int((nf+2)/2) * W/nf * 0.18u' pd='2*int((nf+1)/2) * (W/nf + 0.18u)' ps='2*int((nf+2)/2) * (W/nf + 0.18u)' nrd='0.18u / W' nrs='0.18u / W' sa=0 sb=0 sd=0
VR_m478 nref m478r 0
XO_m478 m478o m478r Vdd Vdd pfet_03v3 L=0.534u W=0.436u nf=1 ad='int((nf+1)/2) * W/nf * 0.18u' as='int((nf+2)/2) * W/nf * 0.18u' pd='2*int((nf+1)/2) * (W/nf + 0.18u)' ps='2*int((nf+2)/2) * (W/nf + 0.18u)' nrd='0.18u / W' nrs='0.18u / W' sa=0 sb=0 sd=0
VO_m478 m478o Vmem 0
XR_m479 m479r m479r Vdd Vdd pfet_03v3 L=2.629u W=3.384u nf=1 ad='int((nf+1)/2) * W/nf * 0.18u' as='int((nf+2)/2) * W/nf * 0.18u' pd='2*int((nf+1)/2) * (W/nf + 0.18u)' ps='2*int((nf+2)/2) * (W/nf + 0.18u)' nrd='0.18u / W' nrs='0.18u / W' sa=0 sb=0 sd=0
VR_m479 nref m479r 0
XO_m479 m479o m479r Vdd Vdd pfet_03v3 L=4.724u W=0.871u nf=1 ad='int((nf+1)/2) * W/nf * 0.18u' as='int((nf+2)/2) * W/nf * 0.18u' pd='2*int((nf+1)/2) * (W/nf + 0.18u)' ps='2*int((nf+2)/2) * (W/nf + 0.18u)' nrd='0.18u / W' nrs='0.18u / W' sa=0 sb=0 sd=0
VO_m479 m479o Vmem 0
XR_m480 m480r m480r Vdd Vdd pfet_03v3 L=2.026u W=0.929u nf=1 ad='int((nf+1)/2) * W/nf * 0.18u' as='int((nf+2)/2) * W/nf * 0.18u' pd='2*int((nf+1)/2) * (W/nf + 0.18u)' ps='2*int((nf+2)/2) * (W/nf + 0.18u)' nrd='0.18u / W' nrs='0.18u / W' sa=0 sb=0 sd=0
VR_m480 nref m480r 0
XO_m480 m480o m480r Vdd Vdd pfet_03v3 L=0.955u W=1.17u nf=1 ad='int((nf+1)/2) * W/nf * 0.18u' as='int((nf+2)/2) * W/nf * 0.18u' pd='2*int((nf+1)/2) * (W/nf + 0.18u)' ps='2*int((nf+2)/2) * (W/nf + 0.18u)' nrd='0.18u / W' nrs='0.18u / W' sa=0 sb=0 sd=0
VO_m480 m480o Vmem 0
XR_m481 m481r m481r Vdd Vdd pfet_03v3 L=3.441u W=0.45u nf=1 ad='int((nf+1)/2) * W/nf * 0.18u' as='int((nf+2)/2) * W/nf * 0.18u' pd='2*int((nf+1)/2) * (W/nf + 0.18u)' ps='2*int((nf+2)/2) * (W/nf + 0.18u)' nrd='0.18u / W' nrs='0.18u / W' sa=0 sb=0 sd=0
VR_m481 nref m481r 0
XO_m481 m481o m481r Vdd Vdd pfet_03v3 L=6.613u W=0.721u nf=1 ad='int((nf+1)/2) * W/nf * 0.18u' as='int((nf+2)/2) * W/nf * 0.18u' pd='2*int((nf+1)/2) * (W/nf + 0.18u)' ps='2*int((nf+2)/2) * (W/nf + 0.18u)' nrd='0.18u / W' nrs='0.18u / W' sa=0 sb=0 sd=0
VO_m481 m481o Vmem 0
XR_m482 m482r m482r Vdd Vdd pfet_03v3 L=0.561u W=2.015u nf=1 ad='int((nf+1)/2) * W/nf * 0.18u' as='int((nf+2)/2) * W/nf * 0.18u' pd='2*int((nf+1)/2) * (W/nf + 0.18u)' ps='2*int((nf+2)/2) * (W/nf + 0.18u)' nrd='0.18u / W' nrs='0.18u / W' sa=0 sb=0 sd=0
VR_m482 nref m482r 0
XO_m482 m482o m482r Vdd Vdd pfet_03v3 L=0.784u W=0.246u nf=1 ad='int((nf+1)/2) * W/nf * 0.18u' as='int((nf+2)/2) * W/nf * 0.18u' pd='2*int((nf+1)/2) * (W/nf + 0.18u)' ps='2*int((nf+2)/2) * (W/nf + 0.18u)' nrd='0.18u / W' nrs='0.18u / W' sa=0 sb=0 sd=0
VO_m482 m482o Vmem 0
XR_m483 m483r m483r Vdd Vdd pfet_03v3 L=0.32u W=1.526u nf=1 ad='int((nf+1)/2) * W/nf * 0.18u' as='int((nf+2)/2) * W/nf * 0.18u' pd='2*int((nf+1)/2) * (W/nf + 0.18u)' ps='2*int((nf+2)/2) * (W/nf + 0.18u)' nrd='0.18u / W' nrs='0.18u / W' sa=0 sb=0 sd=0
VR_m483 nref m483r 0
XO_m483 m483o m483r Vdd Vdd pfet_03v3 L=3.343u W=0.396u nf=1 ad='int((nf+1)/2) * W/nf * 0.18u' as='int((nf+2)/2) * W/nf * 0.18u' pd='2*int((nf+1)/2) * (W/nf + 0.18u)' ps='2*int((nf+2)/2) * (W/nf + 0.18u)' nrd='0.18u / W' nrs='0.18u / W' sa=0 sb=0 sd=0
VO_m483 m483o Vmem 0
XR_m484 m484r m484r Vdd Vdd pfet_03v3 L=0.582u W=1.133u nf=1 ad='int((nf+1)/2) * W/nf * 0.18u' as='int((nf+2)/2) * W/nf * 0.18u' pd='2*int((nf+1)/2) * (W/nf + 0.18u)' ps='2*int((nf+2)/2) * (W/nf + 0.18u)' nrd='0.18u / W' nrs='0.18u / W' sa=0 sb=0 sd=0
VR_m484 nref m484r 0
XO_m484 m484o m484r Vdd Vdd pfet_03v3 L=1.584u W=1.34u nf=1 ad='int((nf+1)/2) * W/nf * 0.18u' as='int((nf+2)/2) * W/nf * 0.18u' pd='2*int((nf+1)/2) * (W/nf + 0.18u)' ps='2*int((nf+2)/2) * (W/nf + 0.18u)' nrd='0.18u / W' nrs='0.18u / W' sa=0 sb=0 sd=0
VO_m484 m484o Vmem 0
XR_m485 m485r m485r Vdd Vdd pfet_03v3 L=2.008u W=0.575u nf=1 ad='int((nf+1)/2) * W/nf * 0.18u' as='int((nf+2)/2) * W/nf * 0.18u' pd='2*int((nf+1)/2) * (W/nf + 0.18u)' ps='2*int((nf+2)/2) * (W/nf + 0.18u)' nrd='0.18u / W' nrs='0.18u / W' sa=0 sb=0 sd=0
VR_m485 nref m485r 0
XO_m485 m485o m485r Vdd Vdd pfet_03v3 L=0.781u W=0.297u nf=1 ad='int((nf+1)/2) * W/nf * 0.18u' as='int((nf+2)/2) * W/nf * 0.18u' pd='2*int((nf+1)/2) * (W/nf + 0.18u)' ps='2*int((nf+2)/2) * (W/nf + 0.18u)' nrd='0.18u / W' nrs='0.18u / W' sa=0 sb=0 sd=0
VO_m485 m485o Vmem 0
XR_m486 m486r m486r Vdd Vdd pfet_03v3 L=0.322u W=2.685u nf=1 ad='int((nf+1)/2) * W/nf * 0.18u' as='int((nf+2)/2) * W/nf * 0.18u' pd='2*int((nf+1)/2) * (W/nf + 0.18u)' ps='2*int((nf+2)/2) * (W/nf + 0.18u)' nrd='0.18u / W' nrs='0.18u / W' sa=0 sb=0 sd=0
VR_m486 nref m486r 0
XO_m486 m486o m486r Vdd Vdd pfet_03v3 L=6.514u W=0.337u nf=1 ad='int((nf+1)/2) * W/nf * 0.18u' as='int((nf+2)/2) * W/nf * 0.18u' pd='2*int((nf+1)/2) * (W/nf + 0.18u)' ps='2*int((nf+2)/2) * (W/nf + 0.18u)' nrd='0.18u / W' nrs='0.18u / W' sa=0 sb=0 sd=0
VO_m486 m486o Vmem 0
XR_m487 m487r m487r Vdd Vdd pfet_03v3 L=0.859u W=1.246u nf=1 ad='int((nf+1)/2) * W/nf * 0.18u' as='int((nf+2)/2) * W/nf * 0.18u' pd='2*int((nf+1)/2) * (W/nf + 0.18u)' ps='2*int((nf+2)/2) * (W/nf + 0.18u)' nrd='0.18u / W' nrs='0.18u / W' sa=0 sb=0 sd=0
VR_m487 nref m487r 0
XO_m487 m487o m487r Vdd Vdd pfet_03v3 L=0.982u W=0.274u nf=1 ad='int((nf+1)/2) * W/nf * 0.18u' as='int((nf+2)/2) * W/nf * 0.18u' pd='2*int((nf+1)/2) * (W/nf + 0.18u)' ps='2*int((nf+2)/2) * (W/nf + 0.18u)' nrd='0.18u / W' nrs='0.18u / W' sa=0 sb=0 sd=0
VO_m487 m487o Vmem 0
XR_m488 m488r m488r Vdd Vdd pfet_03v3 L=3.176u W=3.578u nf=1 ad='int((nf+1)/2) * W/nf * 0.18u' as='int((nf+2)/2) * W/nf * 0.18u' pd='2*int((nf+1)/2) * (W/nf + 0.18u)' ps='2*int((nf+2)/2) * (W/nf + 0.18u)' nrd='0.18u / W' nrs='0.18u / W' sa=0 sb=0 sd=0
VR_m488 nref m488r 0
XO_m488 m488o m488r Vdd Vdd pfet_03v3 L=1.487u W=1.373u nf=1 ad='int((nf+1)/2) * W/nf * 0.18u' as='int((nf+2)/2) * W/nf * 0.18u' pd='2*int((nf+1)/2) * (W/nf + 0.18u)' ps='2*int((nf+2)/2) * (W/nf + 0.18u)' nrd='0.18u / W' nrs='0.18u / W' sa=0 sb=0 sd=0
VO_m488 m488o Vmem 0
XR_m489 m489r m489r Vdd Vdd pfet_03v3 L=1.12u W=2.687u nf=1 ad='int((nf+1)/2) * W/nf * 0.18u' as='int((nf+2)/2) * W/nf * 0.18u' pd='2*int((nf+1)/2) * (W/nf + 0.18u)' ps='2*int((nf+2)/2) * (W/nf + 0.18u)' nrd='0.18u / W' nrs='0.18u / W' sa=0 sb=0 sd=0
VR_m489 nref m489r 0
XO_m489 m489o m489r Vdd Vdd pfet_03v3 L=1.949u W=0.267u nf=1 ad='int((nf+1)/2) * W/nf * 0.18u' as='int((nf+2)/2) * W/nf * 0.18u' pd='2*int((nf+1)/2) * (W/nf + 0.18u)' ps='2*int((nf+2)/2) * (W/nf + 0.18u)' nrd='0.18u / W' nrs='0.18u / W' sa=0 sb=0 sd=0
VO_m489 m489o Vmem 0
XR_m490 m490r m490r Vdd Vdd pfet_03v3 L=2.042u W=1.398u nf=1 ad='int((nf+1)/2) * W/nf * 0.18u' as='int((nf+2)/2) * W/nf * 0.18u' pd='2*int((nf+1)/2) * (W/nf + 0.18u)' ps='2*int((nf+2)/2) * (W/nf + 0.18u)' nrd='0.18u / W' nrs='0.18u / W' sa=0 sb=0 sd=0
VR_m490 nref m490r 0
XO_m490 m490o m490r Vdd Vdd pfet_03v3 L=1.315u W=3.865u nf=1 ad='int((nf+1)/2) * W/nf * 0.18u' as='int((nf+2)/2) * W/nf * 0.18u' pd='2*int((nf+1)/2) * (W/nf + 0.18u)' ps='2*int((nf+2)/2) * (W/nf + 0.18u)' nrd='0.18u / W' nrs='0.18u / W' sa=0 sb=0 sd=0
VO_m490 m490o Vmem 0
XR_m491 m491r m491r Vdd Vdd pfet_03v3 L=0.676u W=0.331u nf=1 ad='int((nf+1)/2) * W/nf * 0.18u' as='int((nf+2)/2) * W/nf * 0.18u' pd='2*int((nf+1)/2) * (W/nf + 0.18u)' ps='2*int((nf+2)/2) * (W/nf + 0.18u)' nrd='0.18u / W' nrs='0.18u / W' sa=0 sb=0 sd=0
VR_m491 nref m491r 0
XO_m491 m491o m491r Vdd Vdd pfet_03v3 L=2.387u W=0.394u nf=1 ad='int((nf+1)/2) * W/nf * 0.18u' as='int((nf+2)/2) * W/nf * 0.18u' pd='2*int((nf+1)/2) * (W/nf + 0.18u)' ps='2*int((nf+2)/2) * (W/nf + 0.18u)' nrd='0.18u / W' nrs='0.18u / W' sa=0 sb=0 sd=0
VO_m491 m491o Vmem 0
XR_m492 m492r m492r Vdd Vdd pfet_03v3 L=0.305u W=1.915u nf=1 ad='int((nf+1)/2) * W/nf * 0.18u' as='int((nf+2)/2) * W/nf * 0.18u' pd='2*int((nf+1)/2) * (W/nf + 0.18u)' ps='2*int((nf+2)/2) * (W/nf + 0.18u)' nrd='0.18u / W' nrs='0.18u / W' sa=0 sb=0 sd=0
VR_m492 nref m492r 0
XO_m492 m492o m492r Vdd Vdd pfet_03v3 L=0.562u W=0.465u nf=1 ad='int((nf+1)/2) * W/nf * 0.18u' as='int((nf+2)/2) * W/nf * 0.18u' pd='2*int((nf+1)/2) * (W/nf + 0.18u)' ps='2*int((nf+2)/2) * (W/nf + 0.18u)' nrd='0.18u / W' nrs='0.18u / W' sa=0 sb=0 sd=0
VO_m492 m492o Vmem 0
XR_m493 m493r m493r Vdd Vdd pfet_03v3 L=0.542u W=0.463u nf=1 ad='int((nf+1)/2) * W/nf * 0.18u' as='int((nf+2)/2) * W/nf * 0.18u' pd='2*int((nf+1)/2) * (W/nf + 0.18u)' ps='2*int((nf+2)/2) * (W/nf + 0.18u)' nrd='0.18u / W' nrs='0.18u / W' sa=0 sb=0 sd=0
VR_m493 nref m493r 0
XO_m493 m493o m493r Vdd Vdd pfet_03v3 L=3.031u W=1.975u nf=1 ad='int((nf+1)/2) * W/nf * 0.18u' as='int((nf+2)/2) * W/nf * 0.18u' pd='2*int((nf+1)/2) * (W/nf + 0.18u)' ps='2*int((nf+2)/2) * (W/nf + 0.18u)' nrd='0.18u / W' nrs='0.18u / W' sa=0 sb=0 sd=0
VO_m493 m493o Vmem 0
XR_m494 m494r m494r Vdd Vdd pfet_03v3 L=0.46u W=2.006u nf=1 ad='int((nf+1)/2) * W/nf * 0.18u' as='int((nf+2)/2) * W/nf * 0.18u' pd='2*int((nf+1)/2) * (W/nf + 0.18u)' ps='2*int((nf+2)/2) * (W/nf + 0.18u)' nrd='0.18u / W' nrs='0.18u / W' sa=0 sb=0 sd=0
VR_m494 nref m494r 0
XO_m494 m494o m494r Vdd Vdd pfet_03v3 L=0.638u W=0.278u nf=1 ad='int((nf+1)/2) * W/nf * 0.18u' as='int((nf+2)/2) * W/nf * 0.18u' pd='2*int((nf+1)/2) * (W/nf + 0.18u)' ps='2*int((nf+2)/2) * (W/nf + 0.18u)' nrd='0.18u / W' nrs='0.18u / W' sa=0 sb=0 sd=0
VO_m494 m494o Vmem 0
XR_m495 m495r m495r Vdd Vdd pfet_03v3 L=1.027u W=3.937u nf=1 ad='int((nf+1)/2) * W/nf * 0.18u' as='int((nf+2)/2) * W/nf * 0.18u' pd='2*int((nf+1)/2) * (W/nf + 0.18u)' ps='2*int((nf+2)/2) * (W/nf + 0.18u)' nrd='0.18u / W' nrs='0.18u / W' sa=0 sb=0 sd=0
VR_m495 nref m495r 0
XO_m495 m495o m495r Vdd Vdd pfet_03v3 L=2.397u W=2.231u nf=1 ad='int((nf+1)/2) * W/nf * 0.18u' as='int((nf+2)/2) * W/nf * 0.18u' pd='2*int((nf+1)/2) * (W/nf + 0.18u)' ps='2*int((nf+2)/2) * (W/nf + 0.18u)' nrd='0.18u / W' nrs='0.18u / W' sa=0 sb=0 sd=0
VO_m495 m495o Vmem 0
XR_m496 m496r m496r Vdd Vdd pfet_03v3 L=0.305u W=3.182u nf=1 ad='int((nf+1)/2) * W/nf * 0.18u' as='int((nf+2)/2) * W/nf * 0.18u' pd='2*int((nf+1)/2) * (W/nf + 0.18u)' ps='2*int((nf+2)/2) * (W/nf + 0.18u)' nrd='0.18u / W' nrs='0.18u / W' sa=0 sb=0 sd=0
VR_m496 nref m496r 0
XO_m496 m496o m496r Vdd Vdd pfet_03v3 L=0.372u W=1.63u nf=1 ad='int((nf+1)/2) * W/nf * 0.18u' as='int((nf+2)/2) * W/nf * 0.18u' pd='2*int((nf+1)/2) * (W/nf + 0.18u)' ps='2*int((nf+2)/2) * (W/nf + 0.18u)' nrd='0.18u / W' nrs='0.18u / W' sa=0 sb=0 sd=0
VO_m496 m496o Vmem 0
XR_m497 m497r m497r Vdd Vdd pfet_03v3 L=3.142u W=2.061u nf=1 ad='int((nf+1)/2) * W/nf * 0.18u' as='int((nf+2)/2) * W/nf * 0.18u' pd='2*int((nf+1)/2) * (W/nf + 0.18u)' ps='2*int((nf+2)/2) * (W/nf + 0.18u)' nrd='0.18u / W' nrs='0.18u / W' sa=0 sb=0 sd=0
VR_m497 nref m497r 0
XO_m497 m497o m497r Vdd Vdd pfet_03v3 L=6.755u W=0.295u nf=1 ad='int((nf+1)/2) * W/nf * 0.18u' as='int((nf+2)/2) * W/nf * 0.18u' pd='2*int((nf+1)/2) * (W/nf + 0.18u)' ps='2*int((nf+2)/2) * (W/nf + 0.18u)' nrd='0.18u / W' nrs='0.18u / W' sa=0 sb=0 sd=0
VO_m497 m497o Vmem 0
XR_m498 m498r m498r Vdd Vdd pfet_03v3 L=2.778u W=2.39u nf=1 ad='int((nf+1)/2) * W/nf * 0.18u' as='int((nf+2)/2) * W/nf * 0.18u' pd='2*int((nf+1)/2) * (W/nf + 0.18u)' ps='2*int((nf+2)/2) * (W/nf + 0.18u)' nrd='0.18u / W' nrs='0.18u / W' sa=0 sb=0 sd=0
VR_m498 nref m498r 0
XO_m498 m498o m498r Vdd Vdd pfet_03v3 L=2.679u W=0.892u nf=1 ad='int((nf+1)/2) * W/nf * 0.18u' as='int((nf+2)/2) * W/nf * 0.18u' pd='2*int((nf+1)/2) * (W/nf + 0.18u)' ps='2*int((nf+2)/2) * (W/nf + 0.18u)' nrd='0.18u / W' nrs='0.18u / W' sa=0 sb=0 sd=0
VO_m498 m498o Vmem 0
XR_m499 m499r m499r Vdd Vdd pfet_03v3 L=1.015u W=0.269u nf=1 ad='int((nf+1)/2) * W/nf * 0.18u' as='int((nf+2)/2) * W/nf * 0.18u' pd='2*int((nf+1)/2) * (W/nf + 0.18u)' ps='2*int((nf+2)/2) * (W/nf + 0.18u)' nrd='0.18u / W' nrs='0.18u / W' sa=0 sb=0 sd=0
VR_m499 nref m499r 0
XO_m499 m499o m499r Vdd Vdd pfet_03v3 L=2.143u W=0.523u nf=1 ad='int((nf+1)/2) * W/nf * 0.18u' as='int((nf+2)/2) * W/nf * 0.18u' pd='2*int((nf+1)/2) * (W/nf + 0.18u)' ps='2*int((nf+2)/2) * (W/nf + 0.18u)' nrd='0.18u / W' nrs='0.18u / W' sa=0 sb=0 sd=0
VO_m499 m499o Vmem 0
XR_m500 m500r m500r Vdd Vdd pfet_03v3 L=1.887u W=0.764u nf=1 ad='int((nf+1)/2) * W/nf * 0.18u' as='int((nf+2)/2) * W/nf * 0.18u' pd='2*int((nf+1)/2) * (W/nf + 0.18u)' ps='2*int((nf+2)/2) * (W/nf + 0.18u)' nrd='0.18u / W' nrs='0.18u / W' sa=0 sb=0 sd=0
VR_m500 nref m500r 0
XO_m500 m500o m500r Vdd Vdd pfet_03v3 L=1.431u W=0.444u nf=1 ad='int((nf+1)/2) * W/nf * 0.18u' as='int((nf+2)/2) * W/nf * 0.18u' pd='2*int((nf+1)/2) * (W/nf + 0.18u)' ps='2*int((nf+2)/2) * (W/nf + 0.18u)' nrd='0.18u / W' nrs='0.18u / W' sa=0 sb=0 sd=0
VO_m500 m500o Vmem 0
XR_m501 m501r m501r Vdd Vdd pfet_03v3 L=2.303u W=0.662u nf=1 ad='int((nf+1)/2) * W/nf * 0.18u' as='int((nf+2)/2) * W/nf * 0.18u' pd='2*int((nf+1)/2) * (W/nf + 0.18u)' ps='2*int((nf+2)/2) * (W/nf + 0.18u)' nrd='0.18u / W' nrs='0.18u / W' sa=0 sb=0 sd=0
VR_m501 nref m501r 0
XO_m501 m501o m501r Vdd Vdd pfet_03v3 L=0.297u W=0.318u nf=1 ad='int((nf+1)/2) * W/nf * 0.18u' as='int((nf+2)/2) * W/nf * 0.18u' pd='2*int((nf+1)/2) * (W/nf + 0.18u)' ps='2*int((nf+2)/2) * (W/nf + 0.18u)' nrd='0.18u / W' nrs='0.18u / W' sa=0 sb=0 sd=0
VO_m501 m501o Vmem 0
XR_m502 m502r m502r Vdd Vdd pfet_03v3 L=0.948u W=1.247u nf=1 ad='int((nf+1)/2) * W/nf * 0.18u' as='int((nf+2)/2) * W/nf * 0.18u' pd='2*int((nf+1)/2) * (W/nf + 0.18u)' ps='2*int((nf+2)/2) * (W/nf + 0.18u)' nrd='0.18u / W' nrs='0.18u / W' sa=0 sb=0 sd=0
VR_m502 nref m502r 0
XO_m502 m502o m502r Vdd Vdd pfet_03v3 L=7.404u W=1.748u nf=1 ad='int((nf+1)/2) * W/nf * 0.18u' as='int((nf+2)/2) * W/nf * 0.18u' pd='2*int((nf+1)/2) * (W/nf + 0.18u)' ps='2*int((nf+2)/2) * (W/nf + 0.18u)' nrd='0.18u / W' nrs='0.18u / W' sa=0 sb=0 sd=0
VO_m502 m502o Vmem 0
XR_m503 m503r m503r Vdd Vdd pfet_03v3 L=3.194u W=0.42u nf=1 ad='int((nf+1)/2) * W/nf * 0.18u' as='int((nf+2)/2) * W/nf * 0.18u' pd='2*int((nf+1)/2) * (W/nf + 0.18u)' ps='2*int((nf+2)/2) * (W/nf + 0.18u)' nrd='0.18u / W' nrs='0.18u / W' sa=0 sb=0 sd=0
VR_m503 nref m503r 0
XO_m503 m503o m503r Vdd Vdd pfet_03v3 L=0.503u W=0.404u nf=1 ad='int((nf+1)/2) * W/nf * 0.18u' as='int((nf+2)/2) * W/nf * 0.18u' pd='2*int((nf+1)/2) * (W/nf + 0.18u)' ps='2*int((nf+2)/2) * (W/nf + 0.18u)' nrd='0.18u / W' nrs='0.18u / W' sa=0 sb=0 sd=0
VO_m503 m503o Vmem 0
XR_m504 m504r m504r Vdd Vdd pfet_03v3 L=0.558u W=0.313u nf=1 ad='int((nf+1)/2) * W/nf * 0.18u' as='int((nf+2)/2) * W/nf * 0.18u' pd='2*int((nf+1)/2) * (W/nf + 0.18u)' ps='2*int((nf+2)/2) * (W/nf + 0.18u)' nrd='0.18u / W' nrs='0.18u / W' sa=0 sb=0 sd=0
VR_m504 nref m504r 0
XO_m504 m504o m504r Vdd Vdd pfet_03v3 L=0.795u W=0.424u nf=1 ad='int((nf+1)/2) * W/nf * 0.18u' as='int((nf+2)/2) * W/nf * 0.18u' pd='2*int((nf+1)/2) * (W/nf + 0.18u)' ps='2*int((nf+2)/2) * (W/nf + 0.18u)' nrd='0.18u / W' nrs='0.18u / W' sa=0 sb=0 sd=0
VO_m504 m504o Vmem 0
XR_m505 m505r m505r Vdd Vdd pfet_03v3 L=0.426u W=2.874u nf=1 ad='int((nf+1)/2) * W/nf * 0.18u' as='int((nf+2)/2) * W/nf * 0.18u' pd='2*int((nf+1)/2) * (W/nf + 0.18u)' ps='2*int((nf+2)/2) * (W/nf + 0.18u)' nrd='0.18u / W' nrs='0.18u / W' sa=0 sb=0 sd=0
VR_m505 nref m505r 0
XO_m505 m505o m505r Vdd Vdd pfet_03v3 L=0.398u W=1.541u nf=1 ad='int((nf+1)/2) * W/nf * 0.18u' as='int((nf+2)/2) * W/nf * 0.18u' pd='2*int((nf+1)/2) * (W/nf + 0.18u)' ps='2*int((nf+2)/2) * (W/nf + 0.18u)' nrd='0.18u / W' nrs='0.18u / W' sa=0 sb=0 sd=0
VO_m505 m505o Vmem 0
XR_m506 m506r m506r Vdd Vdd pfet_03v3 L=0.508u W=0.486u nf=1 ad='int((nf+1)/2) * W/nf * 0.18u' as='int((nf+2)/2) * W/nf * 0.18u' pd='2*int((nf+1)/2) * (W/nf + 0.18u)' ps='2*int((nf+2)/2) * (W/nf + 0.18u)' nrd='0.18u / W' nrs='0.18u / W' sa=0 sb=0 sd=0
VR_m506 nref m506r 0
XO_m506 m506o m506r Vdd Vdd pfet_03v3 L=7.673u W=2.234u nf=1 ad='int((nf+1)/2) * W/nf * 0.18u' as='int((nf+2)/2) * W/nf * 0.18u' pd='2*int((nf+1)/2) * (W/nf + 0.18u)' ps='2*int((nf+2)/2) * (W/nf + 0.18u)' nrd='0.18u / W' nrs='0.18u / W' sa=0 sb=0 sd=0
VO_m506 m506o Vmem 0
XR_m507 m507r m507r Vdd Vdd pfet_03v3 L=0.707u W=0.326u nf=1 ad='int((nf+1)/2) * W/nf * 0.18u' as='int((nf+2)/2) * W/nf * 0.18u' pd='2*int((nf+1)/2) * (W/nf + 0.18u)' ps='2*int((nf+2)/2) * (W/nf + 0.18u)' nrd='0.18u / W' nrs='0.18u / W' sa=0 sb=0 sd=0
VR_m507 nref m507r 0
XO_m507 m507o m507r Vdd Vdd pfet_03v3 L=1.235u W=1.506u nf=1 ad='int((nf+1)/2) * W/nf * 0.18u' as='int((nf+2)/2) * W/nf * 0.18u' pd='2*int((nf+1)/2) * (W/nf + 0.18u)' ps='2*int((nf+2)/2) * (W/nf + 0.18u)' nrd='0.18u / W' nrs='0.18u / W' sa=0 sb=0 sd=0
VO_m507 m507o Vmem 0
XR_m508 m508r m508r Vdd Vdd pfet_03v3 L=2.472u W=0.354u nf=1 ad='int((nf+1)/2) * W/nf * 0.18u' as='int((nf+2)/2) * W/nf * 0.18u' pd='2*int((nf+1)/2) * (W/nf + 0.18u)' ps='2*int((nf+2)/2) * (W/nf + 0.18u)' nrd='0.18u / W' nrs='0.18u / W' sa=0 sb=0 sd=0
VR_m508 nref m508r 0
XO_m508 m508o m508r Vdd Vdd pfet_03v3 L=0.614u W=1.556u nf=1 ad='int((nf+1)/2) * W/nf * 0.18u' as='int((nf+2)/2) * W/nf * 0.18u' pd='2*int((nf+1)/2) * (W/nf + 0.18u)' ps='2*int((nf+2)/2) * (W/nf + 0.18u)' nrd='0.18u / W' nrs='0.18u / W' sa=0 sb=0 sd=0
VO_m508 m508o Vmem 0
XR_m509 m509r m509r Vdd Vdd pfet_03v3 L=0.686u W=1.443u nf=1 ad='int((nf+1)/2) * W/nf * 0.18u' as='int((nf+2)/2) * W/nf * 0.18u' pd='2*int((nf+1)/2) * (W/nf + 0.18u)' ps='2*int((nf+2)/2) * (W/nf + 0.18u)' nrd='0.18u / W' nrs='0.18u / W' sa=0 sb=0 sd=0
VR_m509 nref m509r 0
XO_m509 m509o m509r Vdd Vdd pfet_03v3 L=5.478u W=0.223u nf=1 ad='int((nf+1)/2) * W/nf * 0.18u' as='int((nf+2)/2) * W/nf * 0.18u' pd='2*int((nf+1)/2) * (W/nf + 0.18u)' ps='2*int((nf+2)/2) * (W/nf + 0.18u)' nrd='0.18u / W' nrs='0.18u / W' sa=0 sb=0 sd=0
VO_m509 m509o Vmem 0
XR_m510 m510r m510r Vdd Vdd pfet_03v3 L=0.321u W=0.512u nf=1 ad='int((nf+1)/2) * W/nf * 0.18u' as='int((nf+2)/2) * W/nf * 0.18u' pd='2*int((nf+1)/2) * (W/nf + 0.18u)' ps='2*int((nf+2)/2) * (W/nf + 0.18u)' nrd='0.18u / W' nrs='0.18u / W' sa=0 sb=0 sd=0
VR_m510 nref m510r 0
XO_m510 m510o m510r Vdd Vdd pfet_03v3 L=0.592u W=3.361u nf=1 ad='int((nf+1)/2) * W/nf * 0.18u' as='int((nf+2)/2) * W/nf * 0.18u' pd='2*int((nf+1)/2) * (W/nf + 0.18u)' ps='2*int((nf+2)/2) * (W/nf + 0.18u)' nrd='0.18u / W' nrs='0.18u / W' sa=0 sb=0 sd=0
VO_m510 m510o Vmem 0
XR_m511 m511r m511r Vdd Vdd pfet_03v3 L=0.306u W=3.881u nf=1 ad='int((nf+1)/2) * W/nf * 0.18u' as='int((nf+2)/2) * W/nf * 0.18u' pd='2*int((nf+1)/2) * (W/nf + 0.18u)' ps='2*int((nf+2)/2) * (W/nf + 0.18u)' nrd='0.18u / W' nrs='0.18u / W' sa=0 sb=0 sd=0
VR_m511 nref m511r 0
XO_m511 m511o m511r Vdd Vdd pfet_03v3 L=1.59u W=3.803u nf=1 ad='int((nf+1)/2) * W/nf * 0.18u' as='int((nf+2)/2) * W/nf * 0.18u' pd='2*int((nf+1)/2) * (W/nf + 0.18u)' ps='2*int((nf+2)/2) * (W/nf + 0.18u)' nrd='0.18u / W' nrs='0.18u / W' sa=0 sb=0 sd=0
VO_m511 m511o Vmem 0
XR_m512 m512r m512r Vdd Vdd pfet_03v3 L=0.51u W=0.563u nf=1 ad='int((nf+1)/2) * W/nf * 0.18u' as='int((nf+2)/2) * W/nf * 0.18u' pd='2*int((nf+1)/2) * (W/nf + 0.18u)' ps='2*int((nf+2)/2) * (W/nf + 0.18u)' nrd='0.18u / W' nrs='0.18u / W' sa=0 sb=0 sd=0
VR_m512 nref m512r 0
XO_m512 m512o m512r Vdd Vdd pfet_03v3 L=2.198u W=0.556u nf=1 ad='int((nf+1)/2) * W/nf * 0.18u' as='int((nf+2)/2) * W/nf * 0.18u' pd='2*int((nf+1)/2) * (W/nf + 0.18u)' ps='2*int((nf+2)/2) * (W/nf + 0.18u)' nrd='0.18u / W' nrs='0.18u / W' sa=0 sb=0 sd=0
VO_m512 m512o Vmem 0
XR_m513 m513r m513r Vdd Vdd pfet_03v3 L=3.218u W=3.228u nf=1 ad='int((nf+1)/2) * W/nf * 0.18u' as='int((nf+2)/2) * W/nf * 0.18u' pd='2*int((nf+1)/2) * (W/nf + 0.18u)' ps='2*int((nf+2)/2) * (W/nf + 0.18u)' nrd='0.18u / W' nrs='0.18u / W' sa=0 sb=0 sd=0
VR_m513 nref m513r 0
XO_m513 m513o m513r Vdd Vdd pfet_03v3 L=1.412u W=0.963u nf=1 ad='int((nf+1)/2) * W/nf * 0.18u' as='int((nf+2)/2) * W/nf * 0.18u' pd='2*int((nf+1)/2) * (W/nf + 0.18u)' ps='2*int((nf+2)/2) * (W/nf + 0.18u)' nrd='0.18u / W' nrs='0.18u / W' sa=0 sb=0 sd=0
VO_m513 m513o Vmem 0
XR_m514 m514r m514r Vdd Vdd pfet_03v3 L=0.295u W=0.822u nf=1 ad='int((nf+1)/2) * W/nf * 0.18u' as='int((nf+2)/2) * W/nf * 0.18u' pd='2*int((nf+1)/2) * (W/nf + 0.18u)' ps='2*int((nf+2)/2) * (W/nf + 0.18u)' nrd='0.18u / W' nrs='0.18u / W' sa=0 sb=0 sd=0
VR_m514 nref m514r 0
XO_m514 m514o m514r Vdd Vdd pfet_03v3 L=6.443u W=0.291u nf=1 ad='int((nf+1)/2) * W/nf * 0.18u' as='int((nf+2)/2) * W/nf * 0.18u' pd='2*int((nf+1)/2) * (W/nf + 0.18u)' ps='2*int((nf+2)/2) * (W/nf + 0.18u)' nrd='0.18u / W' nrs='0.18u / W' sa=0 sb=0 sd=0
VO_m514 m514o Vmem 0
XR_m515 m515r m515r Vdd Vdd pfet_03v3 L=2.331u W=2.95u nf=1 ad='int((nf+1)/2) * W/nf * 0.18u' as='int((nf+2)/2) * W/nf * 0.18u' pd='2*int((nf+1)/2) * (W/nf + 0.18u)' ps='2*int((nf+2)/2) * (W/nf + 0.18u)' nrd='0.18u / W' nrs='0.18u / W' sa=0 sb=0 sd=0
VR_m515 nref m515r 0
XO_m515 m515o m515r Vdd Vdd pfet_03v3 L=1.594u W=1.009u nf=1 ad='int((nf+1)/2) * W/nf * 0.18u' as='int((nf+2)/2) * W/nf * 0.18u' pd='2*int((nf+1)/2) * (W/nf + 0.18u)' ps='2*int((nf+2)/2) * (W/nf + 0.18u)' nrd='0.18u / W' nrs='0.18u / W' sa=0 sb=0 sd=0
VO_m515 m515o Vmem 0
XR_m516 m516r m516r Vdd Vdd pfet_03v3 L=1.136u W=0.984u nf=1 ad='int((nf+1)/2) * W/nf * 0.18u' as='int((nf+2)/2) * W/nf * 0.18u' pd='2*int((nf+1)/2) * (W/nf + 0.18u)' ps='2*int((nf+2)/2) * (W/nf + 0.18u)' nrd='0.18u / W' nrs='0.18u / W' sa=0 sb=0 sd=0
VR_m516 nref m516r 0
XO_m516 m516o m516r Vdd Vdd pfet_03v3 L=3.879u W=0.399u nf=1 ad='int((nf+1)/2) * W/nf * 0.18u' as='int((nf+2)/2) * W/nf * 0.18u' pd='2*int((nf+1)/2) * (W/nf + 0.18u)' ps='2*int((nf+2)/2) * (W/nf + 0.18u)' nrd='0.18u / W' nrs='0.18u / W' sa=0 sb=0 sd=0
VO_m516 m516o Vmem 0
XR_m517 m517r m517r Vdd Vdd pfet_03v3 L=0.911u W=1.828u nf=1 ad='int((nf+1)/2) * W/nf * 0.18u' as='int((nf+2)/2) * W/nf * 0.18u' pd='2*int((nf+1)/2) * (W/nf + 0.18u)' ps='2*int((nf+2)/2) * (W/nf + 0.18u)' nrd='0.18u / W' nrs='0.18u / W' sa=0 sb=0 sd=0
VR_m517 nref m517r 0
XO_m517 m517o m517r Vdd Vdd pfet_03v3 L=2.775u W=0.413u nf=1 ad='int((nf+1)/2) * W/nf * 0.18u' as='int((nf+2)/2) * W/nf * 0.18u' pd='2*int((nf+1)/2) * (W/nf + 0.18u)' ps='2*int((nf+2)/2) * (W/nf + 0.18u)' nrd='0.18u / W' nrs='0.18u / W' sa=0 sb=0 sd=0
VO_m517 m517o Vmem 0
XR_m518 m518r m518r Vdd Vdd pfet_03v3 L=0.809u W=0.262u nf=1 ad='int((nf+1)/2) * W/nf * 0.18u' as='int((nf+2)/2) * W/nf * 0.18u' pd='2*int((nf+1)/2) * (W/nf + 0.18u)' ps='2*int((nf+2)/2) * (W/nf + 0.18u)' nrd='0.18u / W' nrs='0.18u / W' sa=0 sb=0 sd=0
VR_m518 nref m518r 0
XO_m518 m518o m518r Vdd Vdd pfet_03v3 L=1.718u W=0.886u nf=1 ad='int((nf+1)/2) * W/nf * 0.18u' as='int((nf+2)/2) * W/nf * 0.18u' pd='2*int((nf+1)/2) * (W/nf + 0.18u)' ps='2*int((nf+2)/2) * (W/nf + 0.18u)' nrd='0.18u / W' nrs='0.18u / W' sa=0 sb=0 sd=0
VO_m518 m518o Vmem 0
XR_m519 m519r m519r Vdd Vdd pfet_03v3 L=0.865u W=0.42u nf=1 ad='int((nf+1)/2) * W/nf * 0.18u' as='int((nf+2)/2) * W/nf * 0.18u' pd='2*int((nf+1)/2) * (W/nf + 0.18u)' ps='2*int((nf+2)/2) * (W/nf + 0.18u)' nrd='0.18u / W' nrs='0.18u / W' sa=0 sb=0 sd=0
VR_m519 nref m519r 0
XO_m519 m519o m519r Vdd Vdd pfet_03v3 L=0.311u W=0.752u nf=1 ad='int((nf+1)/2) * W/nf * 0.18u' as='int((nf+2)/2) * W/nf * 0.18u' pd='2*int((nf+1)/2) * (W/nf + 0.18u)' ps='2*int((nf+2)/2) * (W/nf + 0.18u)' nrd='0.18u / W' nrs='0.18u / W' sa=0 sb=0 sd=0
VO_m519 m519o Vmem 0
XR_m520 m520r m520r Vdd Vdd pfet_03v3 L=0.686u W=2.751u nf=1 ad='int((nf+1)/2) * W/nf * 0.18u' as='int((nf+2)/2) * W/nf * 0.18u' pd='2*int((nf+1)/2) * (W/nf + 0.18u)' ps='2*int((nf+2)/2) * (W/nf + 0.18u)' nrd='0.18u / W' nrs='0.18u / W' sa=0 sb=0 sd=0
VR_m520 nref m520r 0
XO_m520 m520o m520r Vdd Vdd pfet_03v3 L=0.283u W=0.284u nf=1 ad='int((nf+1)/2) * W/nf * 0.18u' as='int((nf+2)/2) * W/nf * 0.18u' pd='2*int((nf+1)/2) * (W/nf + 0.18u)' ps='2*int((nf+2)/2) * (W/nf + 0.18u)' nrd='0.18u / W' nrs='0.18u / W' sa=0 sb=0 sd=0
VO_m520 m520o Vmem 0
XR_m521 m521r m521r Vdd Vdd pfet_03v3 L=2.401u W=2.33u nf=1 ad='int((nf+1)/2) * W/nf * 0.18u' as='int((nf+2)/2) * W/nf * 0.18u' pd='2*int((nf+1)/2) * (W/nf + 0.18u)' ps='2*int((nf+2)/2) * (W/nf + 0.18u)' nrd='0.18u / W' nrs='0.18u / W' sa=0 sb=0 sd=0
VR_m521 nref m521r 0
XO_m521 m521o m521r Vdd Vdd pfet_03v3 L=0.432u W=0.949u nf=1 ad='int((nf+1)/2) * W/nf * 0.18u' as='int((nf+2)/2) * W/nf * 0.18u' pd='2*int((nf+1)/2) * (W/nf + 0.18u)' ps='2*int((nf+2)/2) * (W/nf + 0.18u)' nrd='0.18u / W' nrs='0.18u / W' sa=0 sb=0 sd=0
VO_m521 m521o Vmem 0
XR_m522 m522r m522r Vdd Vdd pfet_03v3 L=0.809u W=1.313u nf=1 ad='int((nf+1)/2) * W/nf * 0.18u' as='int((nf+2)/2) * W/nf * 0.18u' pd='2*int((nf+1)/2) * (W/nf + 0.18u)' ps='2*int((nf+2)/2) * (W/nf + 0.18u)' nrd='0.18u / W' nrs='0.18u / W' sa=0 sb=0 sd=0
VR_m522 nref m522r 0
XO_m522 m522o m522r Vdd Vdd pfet_03v3 L=0.773u W=3.233u nf=1 ad='int((nf+1)/2) * W/nf * 0.18u' as='int((nf+2)/2) * W/nf * 0.18u' pd='2*int((nf+1)/2) * (W/nf + 0.18u)' ps='2*int((nf+2)/2) * (W/nf + 0.18u)' nrd='0.18u / W' nrs='0.18u / W' sa=0 sb=0 sd=0
VO_m522 m522o Vmem 0
XR_m523 m523r m523r Vdd Vdd pfet_03v3 L=3.141u W=0.608u nf=1 ad='int((nf+1)/2) * W/nf * 0.18u' as='int((nf+2)/2) * W/nf * 0.18u' pd='2*int((nf+1)/2) * (W/nf + 0.18u)' ps='2*int((nf+2)/2) * (W/nf + 0.18u)' nrd='0.18u / W' nrs='0.18u / W' sa=0 sb=0 sd=0
VR_m523 nref m523r 0
XO_m523 m523o m523r Vdd Vdd pfet_03v3 L=0.359u W=3.319u nf=1 ad='int((nf+1)/2) * W/nf * 0.18u' as='int((nf+2)/2) * W/nf * 0.18u' pd='2*int((nf+1)/2) * (W/nf + 0.18u)' ps='2*int((nf+2)/2) * (W/nf + 0.18u)' nrd='0.18u / W' nrs='0.18u / W' sa=0 sb=0 sd=0
VO_m523 m523o Vmem 0
XR_m524 m524r m524r Vdd Vdd pfet_03v3 L=2.984u W=2.608u nf=1 ad='int((nf+1)/2) * W/nf * 0.18u' as='int((nf+2)/2) * W/nf * 0.18u' pd='2*int((nf+1)/2) * (W/nf + 0.18u)' ps='2*int((nf+2)/2) * (W/nf + 0.18u)' nrd='0.18u / W' nrs='0.18u / W' sa=0 sb=0 sd=0
VR_m524 nref m524r 0
XO_m524 m524o m524r Vdd Vdd pfet_03v3 L=4.743u W=0.377u nf=1 ad='int((nf+1)/2) * W/nf * 0.18u' as='int((nf+2)/2) * W/nf * 0.18u' pd='2*int((nf+1)/2) * (W/nf + 0.18u)' ps='2*int((nf+2)/2) * (W/nf + 0.18u)' nrd='0.18u / W' nrs='0.18u / W' sa=0 sb=0 sd=0
VO_m524 m524o Vmem 0
XR_m525 m525r m525r Vdd Vdd pfet_03v3 L=2.728u W=0.588u nf=1 ad='int((nf+1)/2) * W/nf * 0.18u' as='int((nf+2)/2) * W/nf * 0.18u' pd='2*int((nf+1)/2) * (W/nf + 0.18u)' ps='2*int((nf+2)/2) * (W/nf + 0.18u)' nrd='0.18u / W' nrs='0.18u / W' sa=0 sb=0 sd=0
VR_m525 nref m525r 0
XO_m525 m525o m525r Vdd Vdd pfet_03v3 L=1.388u W=0.223u nf=1 ad='int((nf+1)/2) * W/nf * 0.18u' as='int((nf+2)/2) * W/nf * 0.18u' pd='2*int((nf+1)/2) * (W/nf + 0.18u)' ps='2*int((nf+2)/2) * (W/nf + 0.18u)' nrd='0.18u / W' nrs='0.18u / W' sa=0 sb=0 sd=0
VO_m525 m525o Vmem 0
XR_m526 m526r m526r Vdd Vdd pfet_03v3 L=0.609u W=0.733u nf=1 ad='int((nf+1)/2) * W/nf * 0.18u' as='int((nf+2)/2) * W/nf * 0.18u' pd='2*int((nf+1)/2) * (W/nf + 0.18u)' ps='2*int((nf+2)/2) * (W/nf + 0.18u)' nrd='0.18u / W' nrs='0.18u / W' sa=0 sb=0 sd=0
VR_m526 nref m526r 0
XO_m526 m526o m526r Vdd Vdd pfet_03v3 L=2.007u W=3.602u nf=1 ad='int((nf+1)/2) * W/nf * 0.18u' as='int((nf+2)/2) * W/nf * 0.18u' pd='2*int((nf+1)/2) * (W/nf + 0.18u)' ps='2*int((nf+2)/2) * (W/nf + 0.18u)' nrd='0.18u / W' nrs='0.18u / W' sa=0 sb=0 sd=0
VO_m526 m526o Vmem 0
XR_m527 m527r m527r Vdd Vdd pfet_03v3 L=2.259u W=3.575u nf=1 ad='int((nf+1)/2) * W/nf * 0.18u' as='int((nf+2)/2) * W/nf * 0.18u' pd='2*int((nf+1)/2) * (W/nf + 0.18u)' ps='2*int((nf+2)/2) * (W/nf + 0.18u)' nrd='0.18u / W' nrs='0.18u / W' sa=0 sb=0 sd=0
VR_m527 nref m527r 0
XO_m527 m527o m527r Vdd Vdd pfet_03v3 L=0.802u W=0.784u nf=1 ad='int((nf+1)/2) * W/nf * 0.18u' as='int((nf+2)/2) * W/nf * 0.18u' pd='2*int((nf+1)/2) * (W/nf + 0.18u)' ps='2*int((nf+2)/2) * (W/nf + 0.18u)' nrd='0.18u / W' nrs='0.18u / W' sa=0 sb=0 sd=0
VO_m527 m527o Vmem 0
XR_m528 m528r m528r Vdd Vdd pfet_03v3 L=0.542u W=0.321u nf=1 ad='int((nf+1)/2) * W/nf * 0.18u' as='int((nf+2)/2) * W/nf * 0.18u' pd='2*int((nf+1)/2) * (W/nf + 0.18u)' ps='2*int((nf+2)/2) * (W/nf + 0.18u)' nrd='0.18u / W' nrs='0.18u / W' sa=0 sb=0 sd=0
VR_m528 nref m528r 0
XO_m528 m528o m528r Vdd Vdd pfet_03v3 L=2.473u W=3.388u nf=1 ad='int((nf+1)/2) * W/nf * 0.18u' as='int((nf+2)/2) * W/nf * 0.18u' pd='2*int((nf+1)/2) * (W/nf + 0.18u)' ps='2*int((nf+2)/2) * (W/nf + 0.18u)' nrd='0.18u / W' nrs='0.18u / W' sa=0 sb=0 sd=0
VO_m528 m528o Vmem 0
XR_m529 m529r m529r Vdd Vdd pfet_03v3 L=0.315u W=0.599u nf=1 ad='int((nf+1)/2) * W/nf * 0.18u' as='int((nf+2)/2) * W/nf * 0.18u' pd='2*int((nf+1)/2) * (W/nf + 0.18u)' ps='2*int((nf+2)/2) * (W/nf + 0.18u)' nrd='0.18u / W' nrs='0.18u / W' sa=0 sb=0 sd=0
VR_m529 nref m529r 0
XO_m529 m529o m529r Vdd Vdd pfet_03v3 L=6.867u W=0.7u nf=1 ad='int((nf+1)/2) * W/nf * 0.18u' as='int((nf+2)/2) * W/nf * 0.18u' pd='2*int((nf+1)/2) * (W/nf + 0.18u)' ps='2*int((nf+2)/2) * (W/nf + 0.18u)' nrd='0.18u / W' nrs='0.18u / W' sa=0 sb=0 sd=0
VO_m529 m529o Vmem 0
XR_m530 m530r m530r Vdd Vdd pfet_03v3 L=0.647u W=0.416u nf=1 ad='int((nf+1)/2) * W/nf * 0.18u' as='int((nf+2)/2) * W/nf * 0.18u' pd='2*int((nf+1)/2) * (W/nf + 0.18u)' ps='2*int((nf+2)/2) * (W/nf + 0.18u)' nrd='0.18u / W' nrs='0.18u / W' sa=0 sb=0 sd=0
VR_m530 nref m530r 0
XO_m530 m530o m530r Vdd Vdd pfet_03v3 L=1.805u W=2.265u nf=1 ad='int((nf+1)/2) * W/nf * 0.18u' as='int((nf+2)/2) * W/nf * 0.18u' pd='2*int((nf+1)/2) * (W/nf + 0.18u)' ps='2*int((nf+2)/2) * (W/nf + 0.18u)' nrd='0.18u / W' nrs='0.18u / W' sa=0 sb=0 sd=0
VO_m530 m530o Vmem 0
XR_m531 m531r m531r Vdd Vdd pfet_03v3 L=3.786u W=0.273u nf=1 ad='int((nf+1)/2) * W/nf * 0.18u' as='int((nf+2)/2) * W/nf * 0.18u' pd='2*int((nf+1)/2) * (W/nf + 0.18u)' ps='2*int((nf+2)/2) * (W/nf + 0.18u)' nrd='0.18u / W' nrs='0.18u / W' sa=0 sb=0 sd=0
VR_m531 nref m531r 0
XO_m531 m531o m531r Vdd Vdd pfet_03v3 L=1.395u W=0.74u nf=1 ad='int((nf+1)/2) * W/nf * 0.18u' as='int((nf+2)/2) * W/nf * 0.18u' pd='2*int((nf+1)/2) * (W/nf + 0.18u)' ps='2*int((nf+2)/2) * (W/nf + 0.18u)' nrd='0.18u / W' nrs='0.18u / W' sa=0 sb=0 sd=0
VO_m531 m531o Vmem 0
XR_m532 m532r m532r Vdd Vdd pfet_03v3 L=1.268u W=1.19u nf=1 ad='int((nf+1)/2) * W/nf * 0.18u' as='int((nf+2)/2) * W/nf * 0.18u' pd='2*int((nf+1)/2) * (W/nf + 0.18u)' ps='2*int((nf+2)/2) * (W/nf + 0.18u)' nrd='0.18u / W' nrs='0.18u / W' sa=0 sb=0 sd=0
VR_m532 nref m532r 0
XO_m532 m532o m532r Vdd Vdd pfet_03v3 L=0.336u W=0.877u nf=1 ad='int((nf+1)/2) * W/nf * 0.18u' as='int((nf+2)/2) * W/nf * 0.18u' pd='2*int((nf+1)/2) * (W/nf + 0.18u)' ps='2*int((nf+2)/2) * (W/nf + 0.18u)' nrd='0.18u / W' nrs='0.18u / W' sa=0 sb=0 sd=0
VO_m532 m532o Vmem 0
XR_m533 m533r m533r Vdd Vdd pfet_03v3 L=3.199u W=3.843u nf=1 ad='int((nf+1)/2) * W/nf * 0.18u' as='int((nf+2)/2) * W/nf * 0.18u' pd='2*int((nf+1)/2) * (W/nf + 0.18u)' ps='2*int((nf+2)/2) * (W/nf + 0.18u)' nrd='0.18u / W' nrs='0.18u / W' sa=0 sb=0 sd=0
VR_m533 nref m533r 0
XO_m533 m533o m533r Vdd Vdd pfet_03v3 L=1.024u W=0.812u nf=1 ad='int((nf+1)/2) * W/nf * 0.18u' as='int((nf+2)/2) * W/nf * 0.18u' pd='2*int((nf+1)/2) * (W/nf + 0.18u)' ps='2*int((nf+2)/2) * (W/nf + 0.18u)' nrd='0.18u / W' nrs='0.18u / W' sa=0 sb=0 sd=0
VO_m533 m533o Vmem 0
XR_m534 m534r m534r Vdd Vdd pfet_03v3 L=0.701u W=0.478u nf=1 ad='int((nf+1)/2) * W/nf * 0.18u' as='int((nf+2)/2) * W/nf * 0.18u' pd='2*int((nf+1)/2) * (W/nf + 0.18u)' ps='2*int((nf+2)/2) * (W/nf + 0.18u)' nrd='0.18u / W' nrs='0.18u / W' sa=0 sb=0 sd=0
VR_m534 nref m534r 0
XO_m534 m534o m534r Vdd Vdd pfet_03v3 L=1.037u W=3.833u nf=1 ad='int((nf+1)/2) * W/nf * 0.18u' as='int((nf+2)/2) * W/nf * 0.18u' pd='2*int((nf+1)/2) * (W/nf + 0.18u)' ps='2*int((nf+2)/2) * (W/nf + 0.18u)' nrd='0.18u / W' nrs='0.18u / W' sa=0 sb=0 sd=0
VO_m534 m534o Vmem 0
XR_m535 m535r m535r Vdd Vdd pfet_03v3 L=1.519u W=0.448u nf=1 ad='int((nf+1)/2) * W/nf * 0.18u' as='int((nf+2)/2) * W/nf * 0.18u' pd='2*int((nf+1)/2) * (W/nf + 0.18u)' ps='2*int((nf+2)/2) * (W/nf + 0.18u)' nrd='0.18u / W' nrs='0.18u / W' sa=0 sb=0 sd=0
VR_m535 nref m535r 0
XO_m535 m535o m535r Vdd Vdd pfet_03v3 L=0.749u W=2.766u nf=1 ad='int((nf+1)/2) * W/nf * 0.18u' as='int((nf+2)/2) * W/nf * 0.18u' pd='2*int((nf+1)/2) * (W/nf + 0.18u)' ps='2*int((nf+2)/2) * (W/nf + 0.18u)' nrd='0.18u / W' nrs='0.18u / W' sa=0 sb=0 sd=0
VO_m535 m535o Vmem 0
XR_m536 m536r m536r Vdd Vdd pfet_03v3 L=0.866u W=2.078u nf=1 ad='int((nf+1)/2) * W/nf * 0.18u' as='int((nf+2)/2) * W/nf * 0.18u' pd='2*int((nf+1)/2) * (W/nf + 0.18u)' ps='2*int((nf+2)/2) * (W/nf + 0.18u)' nrd='0.18u / W' nrs='0.18u / W' sa=0 sb=0 sd=0
VR_m536 nref m536r 0
XO_m536 m536o m536r Vdd Vdd pfet_03v3 L=2.958u W=2.452u nf=1 ad='int((nf+1)/2) * W/nf * 0.18u' as='int((nf+2)/2) * W/nf * 0.18u' pd='2*int((nf+1)/2) * (W/nf + 0.18u)' ps='2*int((nf+2)/2) * (W/nf + 0.18u)' nrd='0.18u / W' nrs='0.18u / W' sa=0 sb=0 sd=0
VO_m536 m536o Vmem 0
XR_m537 m537r m537r Vdd Vdd pfet_03v3 L=0.84u W=2.016u nf=1 ad='int((nf+1)/2) * W/nf * 0.18u' as='int((nf+2)/2) * W/nf * 0.18u' pd='2*int((nf+1)/2) * (W/nf + 0.18u)' ps='2*int((nf+2)/2) * (W/nf + 0.18u)' nrd='0.18u / W' nrs='0.18u / W' sa=0 sb=0 sd=0
VR_m537 nref m537r 0
XO_m537 m537o m537r Vdd Vdd pfet_03v3 L=1.682u W=1.032u nf=1 ad='int((nf+1)/2) * W/nf * 0.18u' as='int((nf+2)/2) * W/nf * 0.18u' pd='2*int((nf+1)/2) * (W/nf + 0.18u)' ps='2*int((nf+2)/2) * (W/nf + 0.18u)' nrd='0.18u / W' nrs='0.18u / W' sa=0 sb=0 sd=0
VO_m537 m537o Vmem 0
XR_m538 m538r m538r Vdd Vdd pfet_03v3 L=0.462u W=0.393u nf=1 ad='int((nf+1)/2) * W/nf * 0.18u' as='int((nf+2)/2) * W/nf * 0.18u' pd='2*int((nf+1)/2) * (W/nf + 0.18u)' ps='2*int((nf+2)/2) * (W/nf + 0.18u)' nrd='0.18u / W' nrs='0.18u / W' sa=0 sb=0 sd=0
VR_m538 nref m538r 0
XO_m538 m538o m538r Vdd Vdd pfet_03v3 L=2.856u W=0.361u nf=1 ad='int((nf+1)/2) * W/nf * 0.18u' as='int((nf+2)/2) * W/nf * 0.18u' pd='2*int((nf+1)/2) * (W/nf + 0.18u)' ps='2*int((nf+2)/2) * (W/nf + 0.18u)' nrd='0.18u / W' nrs='0.18u / W' sa=0 sb=0 sd=0
VO_m538 m538o Vmem 0
XR_m539 m539r m539r Vdd Vdd pfet_03v3 L=2.361u W=3.776u nf=1 ad='int((nf+1)/2) * W/nf * 0.18u' as='int((nf+2)/2) * W/nf * 0.18u' pd='2*int((nf+1)/2) * (W/nf + 0.18u)' ps='2*int((nf+2)/2) * (W/nf + 0.18u)' nrd='0.18u / W' nrs='0.18u / W' sa=0 sb=0 sd=0
VR_m539 nref m539r 0
XO_m539 m539o m539r Vdd Vdd pfet_03v3 L=4.963u W=0.967u nf=1 ad='int((nf+1)/2) * W/nf * 0.18u' as='int((nf+2)/2) * W/nf * 0.18u' pd='2*int((nf+1)/2) * (W/nf + 0.18u)' ps='2*int((nf+2)/2) * (W/nf + 0.18u)' nrd='0.18u / W' nrs='0.18u / W' sa=0 sb=0 sd=0
VO_m539 m539o Vmem 0
XR_m540 m540r m540r Vdd Vdd pfet_03v3 L=0.736u W=0.377u nf=1 ad='int((nf+1)/2) * W/nf * 0.18u' as='int((nf+2)/2) * W/nf * 0.18u' pd='2*int((nf+1)/2) * (W/nf + 0.18u)' ps='2*int((nf+2)/2) * (W/nf + 0.18u)' nrd='0.18u / W' nrs='0.18u / W' sa=0 sb=0 sd=0
VR_m540 nref m540r 0
XO_m540 m540o m540r Vdd Vdd pfet_03v3 L=5.587u W=1.736u nf=1 ad='int((nf+1)/2) * W/nf * 0.18u' as='int((nf+2)/2) * W/nf * 0.18u' pd='2*int((nf+1)/2) * (W/nf + 0.18u)' ps='2*int((nf+2)/2) * (W/nf + 0.18u)' nrd='0.18u / W' nrs='0.18u / W' sa=0 sb=0 sd=0
VO_m540 m540o Vmem 0
XR_m541 m541r m541r Vdd Vdd pfet_03v3 L=2.068u W=2.355u nf=1 ad='int((nf+1)/2) * W/nf * 0.18u' as='int((nf+2)/2) * W/nf * 0.18u' pd='2*int((nf+1)/2) * (W/nf + 0.18u)' ps='2*int((nf+2)/2) * (W/nf + 0.18u)' nrd='0.18u / W' nrs='0.18u / W' sa=0 sb=0 sd=0
VR_m541 nref m541r 0
XO_m541 m541o m541r Vdd Vdd pfet_03v3 L=1.745u W=2.302u nf=1 ad='int((nf+1)/2) * W/nf * 0.18u' as='int((nf+2)/2) * W/nf * 0.18u' pd='2*int((nf+1)/2) * (W/nf + 0.18u)' ps='2*int((nf+2)/2) * (W/nf + 0.18u)' nrd='0.18u / W' nrs='0.18u / W' sa=0 sb=0 sd=0
VO_m541 m541o Vmem 0
XR_m542 m542r m542r Vdd Vdd pfet_03v3 L=0.514u W=1.421u nf=1 ad='int((nf+1)/2) * W/nf * 0.18u' as='int((nf+2)/2) * W/nf * 0.18u' pd='2*int((nf+1)/2) * (W/nf + 0.18u)' ps='2*int((nf+2)/2) * (W/nf + 0.18u)' nrd='0.18u / W' nrs='0.18u / W' sa=0 sb=0 sd=0
VR_m542 nref m542r 0
XO_m542 m542o m542r Vdd Vdd pfet_03v3 L=0.498u W=0.433u nf=1 ad='int((nf+1)/2) * W/nf * 0.18u' as='int((nf+2)/2) * W/nf * 0.18u' pd='2*int((nf+1)/2) * (W/nf + 0.18u)' ps='2*int((nf+2)/2) * (W/nf + 0.18u)' nrd='0.18u / W' nrs='0.18u / W' sa=0 sb=0 sd=0
VO_m542 m542o Vmem 0
XR_m543 m543r m543r Vdd Vdd pfet_03v3 L=0.561u W=1.046u nf=1 ad='int((nf+1)/2) * W/nf * 0.18u' as='int((nf+2)/2) * W/nf * 0.18u' pd='2*int((nf+1)/2) * (W/nf + 0.18u)' ps='2*int((nf+2)/2) * (W/nf + 0.18u)' nrd='0.18u / W' nrs='0.18u / W' sa=0 sb=0 sd=0
VR_m543 nref m543r 0
XO_m543 m543o m543r Vdd Vdd pfet_03v3 L=2.587u W=1.166u nf=1 ad='int((nf+1)/2) * W/nf * 0.18u' as='int((nf+2)/2) * W/nf * 0.18u' pd='2*int((nf+1)/2) * (W/nf + 0.18u)' ps='2*int((nf+2)/2) * (W/nf + 0.18u)' nrd='0.18u / W' nrs='0.18u / W' sa=0 sb=0 sd=0
VO_m543 m543o Vmem 0
XR_m544 m544r m544r Vdd Vdd pfet_03v3 L=1.647u W=1.16u nf=1 ad='int((nf+1)/2) * W/nf * 0.18u' as='int((nf+2)/2) * W/nf * 0.18u' pd='2*int((nf+1)/2) * (W/nf + 0.18u)' ps='2*int((nf+2)/2) * (W/nf + 0.18u)' nrd='0.18u / W' nrs='0.18u / W' sa=0 sb=0 sd=0
VR_m544 nref m544r 0
XO_m544 m544o m544r Vdd Vdd pfet_03v3 L=2.571u W=1.661u nf=1 ad='int((nf+1)/2) * W/nf * 0.18u' as='int((nf+2)/2) * W/nf * 0.18u' pd='2*int((nf+1)/2) * (W/nf + 0.18u)' ps='2*int((nf+2)/2) * (W/nf + 0.18u)' nrd='0.18u / W' nrs='0.18u / W' sa=0 sb=0 sd=0
VO_m544 m544o Vmem 0
XR_m545 m545r m545r Vdd Vdd pfet_03v3 L=1.647u W=1.578u nf=1 ad='int((nf+1)/2) * W/nf * 0.18u' as='int((nf+2)/2) * W/nf * 0.18u' pd='2*int((nf+1)/2) * (W/nf + 0.18u)' ps='2*int((nf+2)/2) * (W/nf + 0.18u)' nrd='0.18u / W' nrs='0.18u / W' sa=0 sb=0 sd=0
VR_m545 nref m545r 0
XO_m545 m545o m545r Vdd Vdd pfet_03v3 L=0.483u W=2.303u nf=1 ad='int((nf+1)/2) * W/nf * 0.18u' as='int((nf+2)/2) * W/nf * 0.18u' pd='2*int((nf+1)/2) * (W/nf + 0.18u)' ps='2*int((nf+2)/2) * (W/nf + 0.18u)' nrd='0.18u / W' nrs='0.18u / W' sa=0 sb=0 sd=0
VO_m545 m545o Vmem 0
XR_m546 m546r m546r Vdd Vdd pfet_03v3 L=3.75u W=2.443u nf=1 ad='int((nf+1)/2) * W/nf * 0.18u' as='int((nf+2)/2) * W/nf * 0.18u' pd='2*int((nf+1)/2) * (W/nf + 0.18u)' ps='2*int((nf+2)/2) * (W/nf + 0.18u)' nrd='0.18u / W' nrs='0.18u / W' sa=0 sb=0 sd=0
VR_m546 nref m546r 0
XO_m546 m546o m546r Vdd Vdd pfet_03v3 L=0.529u W=1.927u nf=1 ad='int((nf+1)/2) * W/nf * 0.18u' as='int((nf+2)/2) * W/nf * 0.18u' pd='2*int((nf+1)/2) * (W/nf + 0.18u)' ps='2*int((nf+2)/2) * (W/nf + 0.18u)' nrd='0.18u / W' nrs='0.18u / W' sa=0 sb=0 sd=0
VO_m546 m546o Vmem 0
XR_m547 m547r m547r Vdd Vdd pfet_03v3 L=1.163u W=0.633u nf=1 ad='int((nf+1)/2) * W/nf * 0.18u' as='int((nf+2)/2) * W/nf * 0.18u' pd='2*int((nf+1)/2) * (W/nf + 0.18u)' ps='2*int((nf+2)/2) * (W/nf + 0.18u)' nrd='0.18u / W' nrs='0.18u / W' sa=0 sb=0 sd=0
VR_m547 nref m547r 0
XO_m547 m547o m547r Vdd Vdd pfet_03v3 L=0.556u W=1.764u nf=1 ad='int((nf+1)/2) * W/nf * 0.18u' as='int((nf+2)/2) * W/nf * 0.18u' pd='2*int((nf+1)/2) * (W/nf + 0.18u)' ps='2*int((nf+2)/2) * (W/nf + 0.18u)' nrd='0.18u / W' nrs='0.18u / W' sa=0 sb=0 sd=0
VO_m547 m547o Vmem 0
XR_m548 m548r m548r Vdd Vdd pfet_03v3 L=0.512u W=1.284u nf=1 ad='int((nf+1)/2) * W/nf * 0.18u' as='int((nf+2)/2) * W/nf * 0.18u' pd='2*int((nf+1)/2) * (W/nf + 0.18u)' ps='2*int((nf+2)/2) * (W/nf + 0.18u)' nrd='0.18u / W' nrs='0.18u / W' sa=0 sb=0 sd=0
VR_m548 nref m548r 0
XO_m548 m548o m548r Vdd Vdd pfet_03v3 L=1.108u W=0.641u nf=1 ad='int((nf+1)/2) * W/nf * 0.18u' as='int((nf+2)/2) * W/nf * 0.18u' pd='2*int((nf+1)/2) * (W/nf + 0.18u)' ps='2*int((nf+2)/2) * (W/nf + 0.18u)' nrd='0.18u / W' nrs='0.18u / W' sa=0 sb=0 sd=0
VO_m548 m548o Vmem 0
XR_m549 m549r m549r Vdd Vdd pfet_03v3 L=0.648u W=1.001u nf=1 ad='int((nf+1)/2) * W/nf * 0.18u' as='int((nf+2)/2) * W/nf * 0.18u' pd='2*int((nf+1)/2) * (W/nf + 0.18u)' ps='2*int((nf+2)/2) * (W/nf + 0.18u)' nrd='0.18u / W' nrs='0.18u / W' sa=0 sb=0 sd=0
VR_m549 nref m549r 0
XO_m549 m549o m549r Vdd Vdd pfet_03v3 L=0.513u W=1.909u nf=1 ad='int((nf+1)/2) * W/nf * 0.18u' as='int((nf+2)/2) * W/nf * 0.18u' pd='2*int((nf+1)/2) * (W/nf + 0.18u)' ps='2*int((nf+2)/2) * (W/nf + 0.18u)' nrd='0.18u / W' nrs='0.18u / W' sa=0 sb=0 sd=0
VO_m549 m549o Vmem 0
XR_m550 m550r m550r Vdd Vdd pfet_03v3 L=3.084u W=1.574u nf=1 ad='int((nf+1)/2) * W/nf * 0.18u' as='int((nf+2)/2) * W/nf * 0.18u' pd='2*int((nf+1)/2) * (W/nf + 0.18u)' ps='2*int((nf+2)/2) * (W/nf + 0.18u)' nrd='0.18u / W' nrs='0.18u / W' sa=0 sb=0 sd=0
VR_m550 nref m550r 0
XO_m550 m550o m550r Vdd Vdd pfet_03v3 L=2.132u W=0.859u nf=1 ad='int((nf+1)/2) * W/nf * 0.18u' as='int((nf+2)/2) * W/nf * 0.18u' pd='2*int((nf+1)/2) * (W/nf + 0.18u)' ps='2*int((nf+2)/2) * (W/nf + 0.18u)' nrd='0.18u / W' nrs='0.18u / W' sa=0 sb=0 sd=0
VO_m550 m550o Vmem 0
XR_m551 m551r m551r Vdd Vdd pfet_03v3 L=1.252u W=0.8u nf=1 ad='int((nf+1)/2) * W/nf * 0.18u' as='int((nf+2)/2) * W/nf * 0.18u' pd='2*int((nf+1)/2) * (W/nf + 0.18u)' ps='2*int((nf+2)/2) * (W/nf + 0.18u)' nrd='0.18u / W' nrs='0.18u / W' sa=0 sb=0 sd=0
VR_m551 nref m551r 0
XO_m551 m551o m551r Vdd Vdd pfet_03v3 L=0.657u W=3.617u nf=1 ad='int((nf+1)/2) * W/nf * 0.18u' as='int((nf+2)/2) * W/nf * 0.18u' pd='2*int((nf+1)/2) * (W/nf + 0.18u)' ps='2*int((nf+2)/2) * (W/nf + 0.18u)' nrd='0.18u / W' nrs='0.18u / W' sa=0 sb=0 sd=0
VO_m551 m551o Vmem 0
XR_m552 m552r m552r Vdd Vdd pfet_03v3 L=0.363u W=2.2u nf=1 ad='int((nf+1)/2) * W/nf * 0.18u' as='int((nf+2)/2) * W/nf * 0.18u' pd='2*int((nf+1)/2) * (W/nf + 0.18u)' ps='2*int((nf+2)/2) * (W/nf + 0.18u)' nrd='0.18u / W' nrs='0.18u / W' sa=0 sb=0 sd=0
VR_m552 nref m552r 0
XO_m552 m552o m552r Vdd Vdd pfet_03v3 L=0.749u W=0.238u nf=1 ad='int((nf+1)/2) * W/nf * 0.18u' as='int((nf+2)/2) * W/nf * 0.18u' pd='2*int((nf+1)/2) * (W/nf + 0.18u)' ps='2*int((nf+2)/2) * (W/nf + 0.18u)' nrd='0.18u / W' nrs='0.18u / W' sa=0 sb=0 sd=0
VO_m552 m552o Vmem 0
XR_m553 m553r m553r Vdd Vdd pfet_03v3 L=0.643u W=1.252u nf=1 ad='int((nf+1)/2) * W/nf * 0.18u' as='int((nf+2)/2) * W/nf * 0.18u' pd='2*int((nf+1)/2) * (W/nf + 0.18u)' ps='2*int((nf+2)/2) * (W/nf + 0.18u)' nrd='0.18u / W' nrs='0.18u / W' sa=0 sb=0 sd=0
VR_m553 nref m553r 0
XO_m553 m553o m553r Vdd Vdd pfet_03v3 L=2.612u W=3.893u nf=1 ad='int((nf+1)/2) * W/nf * 0.18u' as='int((nf+2)/2) * W/nf * 0.18u' pd='2*int((nf+1)/2) * (W/nf + 0.18u)' ps='2*int((nf+2)/2) * (W/nf + 0.18u)' nrd='0.18u / W' nrs='0.18u / W' sa=0 sb=0 sd=0
VO_m553 m553o Vmem 0
XR_m554 m554r m554r Vdd Vdd pfet_03v3 L=0.637u W=1.311u nf=1 ad='int((nf+1)/2) * W/nf * 0.18u' as='int((nf+2)/2) * W/nf * 0.18u' pd='2*int((nf+1)/2) * (W/nf + 0.18u)' ps='2*int((nf+2)/2) * (W/nf + 0.18u)' nrd='0.18u / W' nrs='0.18u / W' sa=0 sb=0 sd=0
VR_m554 nref m554r 0
XO_m554 m554o m554r Vdd Vdd pfet_03v3 L=0.404u W=1.063u nf=1 ad='int((nf+1)/2) * W/nf * 0.18u' as='int((nf+2)/2) * W/nf * 0.18u' pd='2*int((nf+1)/2) * (W/nf + 0.18u)' ps='2*int((nf+2)/2) * (W/nf + 0.18u)' nrd='0.18u / W' nrs='0.18u / W' sa=0 sb=0 sd=0
VO_m554 m554o Vmem 0
XR_m555 m555r m555r Vdd Vdd pfet_03v3 L=3.786u W=0.725u nf=1 ad='int((nf+1)/2) * W/nf * 0.18u' as='int((nf+2)/2) * W/nf * 0.18u' pd='2*int((nf+1)/2) * (W/nf + 0.18u)' ps='2*int((nf+2)/2) * (W/nf + 0.18u)' nrd='0.18u / W' nrs='0.18u / W' sa=0 sb=0 sd=0
VR_m555 nref m555r 0
XO_m555 m555o m555r Vdd Vdd pfet_03v3 L=0.683u W=0.682u nf=1 ad='int((nf+1)/2) * W/nf * 0.18u' as='int((nf+2)/2) * W/nf * 0.18u' pd='2*int((nf+1)/2) * (W/nf + 0.18u)' ps='2*int((nf+2)/2) * (W/nf + 0.18u)' nrd='0.18u / W' nrs='0.18u / W' sa=0 sb=0 sd=0
VO_m555 m555o Vmem 0
XR_m556 m556r m556r Vdd Vdd pfet_03v3 L=2.915u W=0.463u nf=1 ad='int((nf+1)/2) * W/nf * 0.18u' as='int((nf+2)/2) * W/nf * 0.18u' pd='2*int((nf+1)/2) * (W/nf + 0.18u)' ps='2*int((nf+2)/2) * (W/nf + 0.18u)' nrd='0.18u / W' nrs='0.18u / W' sa=0 sb=0 sd=0
VR_m556 nref m556r 0
XO_m556 m556o m556r Vdd Vdd pfet_03v3 L=2.571u W=0.733u nf=1 ad='int((nf+1)/2) * W/nf * 0.18u' as='int((nf+2)/2) * W/nf * 0.18u' pd='2*int((nf+1)/2) * (W/nf + 0.18u)' ps='2*int((nf+2)/2) * (W/nf + 0.18u)' nrd='0.18u / W' nrs='0.18u / W' sa=0 sb=0 sd=0
VO_m556 m556o Vmem 0
XR_m557 m557r m557r Vdd Vdd pfet_03v3 L=0.35u W=1.097u nf=1 ad='int((nf+1)/2) * W/nf * 0.18u' as='int((nf+2)/2) * W/nf * 0.18u' pd='2*int((nf+1)/2) * (W/nf + 0.18u)' ps='2*int((nf+2)/2) * (W/nf + 0.18u)' nrd='0.18u / W' nrs='0.18u / W' sa=0 sb=0 sd=0
VR_m557 nref m557r 0
XO_m557 m557o m557r Vdd Vdd pfet_03v3 L=1.503u W=3.336u nf=1 ad='int((nf+1)/2) * W/nf * 0.18u' as='int((nf+2)/2) * W/nf * 0.18u' pd='2*int((nf+1)/2) * (W/nf + 0.18u)' ps='2*int((nf+2)/2) * (W/nf + 0.18u)' nrd='0.18u / W' nrs='0.18u / W' sa=0 sb=0 sd=0
VO_m557 m557o Vmem 0
XR_m558 m558r m558r Vdd Vdd pfet_03v3 L=2.281u W=0.972u nf=1 ad='int((nf+1)/2) * W/nf * 0.18u' as='int((nf+2)/2) * W/nf * 0.18u' pd='2*int((nf+1)/2) * (W/nf + 0.18u)' ps='2*int((nf+2)/2) * (W/nf + 0.18u)' nrd='0.18u / W' nrs='0.18u / W' sa=0 sb=0 sd=0
VR_m558 nref m558r 0
XO_m558 m558o m558r Vdd Vdd pfet_03v3 L=0.785u W=2.946u nf=1 ad='int((nf+1)/2) * W/nf * 0.18u' as='int((nf+2)/2) * W/nf * 0.18u' pd='2*int((nf+1)/2) * (W/nf + 0.18u)' ps='2*int((nf+2)/2) * (W/nf + 0.18u)' nrd='0.18u / W' nrs='0.18u / W' sa=0 sb=0 sd=0
VO_m558 m558o Vmem 0
XR_m559 m559r m559r Vdd Vdd pfet_03v3 L=0.407u W=0.325u nf=1 ad='int((nf+1)/2) * W/nf * 0.18u' as='int((nf+2)/2) * W/nf * 0.18u' pd='2*int((nf+1)/2) * (W/nf + 0.18u)' ps='2*int((nf+2)/2) * (W/nf + 0.18u)' nrd='0.18u / W' nrs='0.18u / W' sa=0 sb=0 sd=0
VR_m559 nref m559r 0
XO_m559 m559o m559r Vdd Vdd pfet_03v3 L=1.64u W=0.838u nf=1 ad='int((nf+1)/2) * W/nf * 0.18u' as='int((nf+2)/2) * W/nf * 0.18u' pd='2*int((nf+1)/2) * (W/nf + 0.18u)' ps='2*int((nf+2)/2) * (W/nf + 0.18u)' nrd='0.18u / W' nrs='0.18u / W' sa=0 sb=0 sd=0
VO_m559 m559o Vmem 0
XR_m560 m560r m560r Vdd Vdd pfet_03v3 L=0.314u W=0.508u nf=1 ad='int((nf+1)/2) * W/nf * 0.18u' as='int((nf+2)/2) * W/nf * 0.18u' pd='2*int((nf+1)/2) * (W/nf + 0.18u)' ps='2*int((nf+2)/2) * (W/nf + 0.18u)' nrd='0.18u / W' nrs='0.18u / W' sa=0 sb=0 sd=0
VR_m560 nref m560r 0
XO_m560 m560o m560r Vdd Vdd pfet_03v3 L=2.098u W=2.242u nf=1 ad='int((nf+1)/2) * W/nf * 0.18u' as='int((nf+2)/2) * W/nf * 0.18u' pd='2*int((nf+1)/2) * (W/nf + 0.18u)' ps='2*int((nf+2)/2) * (W/nf + 0.18u)' nrd='0.18u / W' nrs='0.18u / W' sa=0 sb=0 sd=0
VO_m560 m560o Vmem 0
XR_m561 m561r m561r Vdd Vdd pfet_03v3 L=0.549u W=0.435u nf=1 ad='int((nf+1)/2) * W/nf * 0.18u' as='int((nf+2)/2) * W/nf * 0.18u' pd='2*int((nf+1)/2) * (W/nf + 0.18u)' ps='2*int((nf+2)/2) * (W/nf + 0.18u)' nrd='0.18u / W' nrs='0.18u / W' sa=0 sb=0 sd=0
VR_m561 nref m561r 0
XO_m561 m561o m561r Vdd Vdd pfet_03v3 L=0.487u W=0.319u nf=1 ad='int((nf+1)/2) * W/nf * 0.18u' as='int((nf+2)/2) * W/nf * 0.18u' pd='2*int((nf+1)/2) * (W/nf + 0.18u)' ps='2*int((nf+2)/2) * (W/nf + 0.18u)' nrd='0.18u / W' nrs='0.18u / W' sa=0 sb=0 sd=0
VO_m561 m561o Vmem 0
XR_m562 m562r m562r Vdd Vdd pfet_03v3 L=1.152u W=1.396u nf=1 ad='int((nf+1)/2) * W/nf * 0.18u' as='int((nf+2)/2) * W/nf * 0.18u' pd='2*int((nf+1)/2) * (W/nf + 0.18u)' ps='2*int((nf+2)/2) * (W/nf + 0.18u)' nrd='0.18u / W' nrs='0.18u / W' sa=0 sb=0 sd=0
VR_m562 nref m562r 0
XO_m562 m562o m562r Vdd Vdd pfet_03v3 L=2.376u W=0.654u nf=1 ad='int((nf+1)/2) * W/nf * 0.18u' as='int((nf+2)/2) * W/nf * 0.18u' pd='2*int((nf+1)/2) * (W/nf + 0.18u)' ps='2*int((nf+2)/2) * (W/nf + 0.18u)' nrd='0.18u / W' nrs='0.18u / W' sa=0 sb=0 sd=0
VO_m562 m562o Vmem 0
XR_m563 m563r m563r Vdd Vdd pfet_03v3 L=2.491u W=0.723u nf=1 ad='int((nf+1)/2) * W/nf * 0.18u' as='int((nf+2)/2) * W/nf * 0.18u' pd='2*int((nf+1)/2) * (W/nf + 0.18u)' ps='2*int((nf+2)/2) * (W/nf + 0.18u)' nrd='0.18u / W' nrs='0.18u / W' sa=0 sb=0 sd=0
VR_m563 nref m563r 0
XO_m563 m563o m563r Vdd Vdd pfet_03v3 L=3.358u W=3.617u nf=1 ad='int((nf+1)/2) * W/nf * 0.18u' as='int((nf+2)/2) * W/nf * 0.18u' pd='2*int((nf+1)/2) * (W/nf + 0.18u)' ps='2*int((nf+2)/2) * (W/nf + 0.18u)' nrd='0.18u / W' nrs='0.18u / W' sa=0 sb=0 sd=0
VO_m563 m563o Vmem 0
XR_m564 m564r m564r Vdd Vdd pfet_03v3 L=0.343u W=0.637u nf=1 ad='int((nf+1)/2) * W/nf * 0.18u' as='int((nf+2)/2) * W/nf * 0.18u' pd='2*int((nf+1)/2) * (W/nf + 0.18u)' ps='2*int((nf+2)/2) * (W/nf + 0.18u)' nrd='0.18u / W' nrs='0.18u / W' sa=0 sb=0 sd=0
VR_m564 nref m564r 0
XO_m564 m564o m564r Vdd Vdd pfet_03v3 L=1.817u W=2.605u nf=1 ad='int((nf+1)/2) * W/nf * 0.18u' as='int((nf+2)/2) * W/nf * 0.18u' pd='2*int((nf+1)/2) * (W/nf + 0.18u)' ps='2*int((nf+2)/2) * (W/nf + 0.18u)' nrd='0.18u / W' nrs='0.18u / W' sa=0 sb=0 sd=0
VO_m564 m564o Vmem 0
XR_m565 m565r m565r Vdd Vdd pfet_03v3 L=0.388u W=3.595u nf=1 ad='int((nf+1)/2) * W/nf * 0.18u' as='int((nf+2)/2) * W/nf * 0.18u' pd='2*int((nf+1)/2) * (W/nf + 0.18u)' ps='2*int((nf+2)/2) * (W/nf + 0.18u)' nrd='0.18u / W' nrs='0.18u / W' sa=0 sb=0 sd=0
VR_m565 nref m565r 0
XO_m565 m565o m565r Vdd Vdd pfet_03v3 L=1.872u W=0.224u nf=1 ad='int((nf+1)/2) * W/nf * 0.18u' as='int((nf+2)/2) * W/nf * 0.18u' pd='2*int((nf+1)/2) * (W/nf + 0.18u)' ps='2*int((nf+2)/2) * (W/nf + 0.18u)' nrd='0.18u / W' nrs='0.18u / W' sa=0 sb=0 sd=0
VO_m565 m565o Vmem 0
XR_m566 m566r m566r Vdd Vdd pfet_03v3 L=3.42u W=0.237u nf=1 ad='int((nf+1)/2) * W/nf * 0.18u' as='int((nf+2)/2) * W/nf * 0.18u' pd='2*int((nf+1)/2) * (W/nf + 0.18u)' ps='2*int((nf+2)/2) * (W/nf + 0.18u)' nrd='0.18u / W' nrs='0.18u / W' sa=0 sb=0 sd=0
VR_m566 nref m566r 0
XO_m566 m566o m566r Vdd Vdd pfet_03v3 L=0.689u W=0.735u nf=1 ad='int((nf+1)/2) * W/nf * 0.18u' as='int((nf+2)/2) * W/nf * 0.18u' pd='2*int((nf+1)/2) * (W/nf + 0.18u)' ps='2*int((nf+2)/2) * (W/nf + 0.18u)' nrd='0.18u / W' nrs='0.18u / W' sa=0 sb=0 sd=0
VO_m566 m566o Vmem 0
XR_m567 m567r m567r Vdd Vdd pfet_03v3 L=0.444u W=1.904u nf=1 ad='int((nf+1)/2) * W/nf * 0.18u' as='int((nf+2)/2) * W/nf * 0.18u' pd='2*int((nf+1)/2) * (W/nf + 0.18u)' ps='2*int((nf+2)/2) * (W/nf + 0.18u)' nrd='0.18u / W' nrs='0.18u / W' sa=0 sb=0 sd=0
VR_m567 nref m567r 0
XO_m567 m567o m567r Vdd Vdd pfet_03v3 L=2.515u W=2.055u nf=1 ad='int((nf+1)/2) * W/nf * 0.18u' as='int((nf+2)/2) * W/nf * 0.18u' pd='2*int((nf+1)/2) * (W/nf + 0.18u)' ps='2*int((nf+2)/2) * (W/nf + 0.18u)' nrd='0.18u / W' nrs='0.18u / W' sa=0 sb=0 sd=0
VO_m567 m567o Vmem 0
XR_m568 m568r m568r Vdd Vdd pfet_03v3 L=1.389u W=0.559u nf=1 ad='int((nf+1)/2) * W/nf * 0.18u' as='int((nf+2)/2) * W/nf * 0.18u' pd='2*int((nf+1)/2) * (W/nf + 0.18u)' ps='2*int((nf+2)/2) * (W/nf + 0.18u)' nrd='0.18u / W' nrs='0.18u / W' sa=0 sb=0 sd=0
VR_m568 nref m568r 0
XO_m568 m568o m568r Vdd Vdd pfet_03v3 L=1.503u W=0.939u nf=1 ad='int((nf+1)/2) * W/nf * 0.18u' as='int((nf+2)/2) * W/nf * 0.18u' pd='2*int((nf+1)/2) * (W/nf + 0.18u)' ps='2*int((nf+2)/2) * (W/nf + 0.18u)' nrd='0.18u / W' nrs='0.18u / W' sa=0 sb=0 sd=0
VO_m568 m568o Vmem 0
XR_m569 m569r m569r Vdd Vdd pfet_03v3 L=1.729u W=0.349u nf=1 ad='int((nf+1)/2) * W/nf * 0.18u' as='int((nf+2)/2) * W/nf * 0.18u' pd='2*int((nf+1)/2) * (W/nf + 0.18u)' ps='2*int((nf+2)/2) * (W/nf + 0.18u)' nrd='0.18u / W' nrs='0.18u / W' sa=0 sb=0 sd=0
VR_m569 nref m569r 0
XO_m569 m569o m569r Vdd Vdd pfet_03v3 L=0.386u W=0.546u nf=1 ad='int((nf+1)/2) * W/nf * 0.18u' as='int((nf+2)/2) * W/nf * 0.18u' pd='2*int((nf+1)/2) * (W/nf + 0.18u)' ps='2*int((nf+2)/2) * (W/nf + 0.18u)' nrd='0.18u / W' nrs='0.18u / W' sa=0 sb=0 sd=0
VO_m569 m569o Vmem 0
XR_m570 m570r m570r Vdd Vdd pfet_03v3 L=0.734u W=0.584u nf=1 ad='int((nf+1)/2) * W/nf * 0.18u' as='int((nf+2)/2) * W/nf * 0.18u' pd='2*int((nf+1)/2) * (W/nf + 0.18u)' ps='2*int((nf+2)/2) * (W/nf + 0.18u)' nrd='0.18u / W' nrs='0.18u / W' sa=0 sb=0 sd=0
VR_m570 nref m570r 0
XO_m570 m570o m570r Vdd Vdd pfet_03v3 L=0.368u W=0.448u nf=1 ad='int((nf+1)/2) * W/nf * 0.18u' as='int((nf+2)/2) * W/nf * 0.18u' pd='2*int((nf+1)/2) * (W/nf + 0.18u)' ps='2*int((nf+2)/2) * (W/nf + 0.18u)' nrd='0.18u / W' nrs='0.18u / W' sa=0 sb=0 sd=0
VO_m570 m570o Vmem 0
XR_m571 m571r m571r Vdd Vdd pfet_03v3 L=0.618u W=1.248u nf=1 ad='int((nf+1)/2) * W/nf * 0.18u' as='int((nf+2)/2) * W/nf * 0.18u' pd='2*int((nf+1)/2) * (W/nf + 0.18u)' ps='2*int((nf+2)/2) * (W/nf + 0.18u)' nrd='0.18u / W' nrs='0.18u / W' sa=0 sb=0 sd=0
VR_m571 nref m571r 0
XO_m571 m571o m571r Vdd Vdd pfet_03v3 L=0.53u W=0.225u nf=1 ad='int((nf+1)/2) * W/nf * 0.18u' as='int((nf+2)/2) * W/nf * 0.18u' pd='2*int((nf+1)/2) * (W/nf + 0.18u)' ps='2*int((nf+2)/2) * (W/nf + 0.18u)' nrd='0.18u / W' nrs='0.18u / W' sa=0 sb=0 sd=0
VO_m571 m571o Vmem 0
XR_m572 m572r m572r Vdd Vdd pfet_03v3 L=1.631u W=0.429u nf=1 ad='int((nf+1)/2) * W/nf * 0.18u' as='int((nf+2)/2) * W/nf * 0.18u' pd='2*int((nf+1)/2) * (W/nf + 0.18u)' ps='2*int((nf+2)/2) * (W/nf + 0.18u)' nrd='0.18u / W' nrs='0.18u / W' sa=0 sb=0 sd=0
VR_m572 nref m572r 0
XO_m572 m572o m572r Vdd Vdd pfet_03v3 L=0.374u W=1.212u nf=1 ad='int((nf+1)/2) * W/nf * 0.18u' as='int((nf+2)/2) * W/nf * 0.18u' pd='2*int((nf+1)/2) * (W/nf + 0.18u)' ps='2*int((nf+2)/2) * (W/nf + 0.18u)' nrd='0.18u / W' nrs='0.18u / W' sa=0 sb=0 sd=0
VO_m572 m572o Vmem 0
XR_m573 m573r m573r Vdd Vdd pfet_03v3 L=1.959u W=0.794u nf=1 ad='int((nf+1)/2) * W/nf * 0.18u' as='int((nf+2)/2) * W/nf * 0.18u' pd='2*int((nf+1)/2) * (W/nf + 0.18u)' ps='2*int((nf+2)/2) * (W/nf + 0.18u)' nrd='0.18u / W' nrs='0.18u / W' sa=0 sb=0 sd=0
VR_m573 nref m573r 0
XO_m573 m573o m573r Vdd Vdd pfet_03v3 L=0.995u W=1.147u nf=1 ad='int((nf+1)/2) * W/nf * 0.18u' as='int((nf+2)/2) * W/nf * 0.18u' pd='2*int((nf+1)/2) * (W/nf + 0.18u)' ps='2*int((nf+2)/2) * (W/nf + 0.18u)' nrd='0.18u / W' nrs='0.18u / W' sa=0 sb=0 sd=0
VO_m573 m573o Vmem 0
XR_m574 m574r m574r Vdd Vdd pfet_03v3 L=0.632u W=3.202u nf=1 ad='int((nf+1)/2) * W/nf * 0.18u' as='int((nf+2)/2) * W/nf * 0.18u' pd='2*int((nf+1)/2) * (W/nf + 0.18u)' ps='2*int((nf+2)/2) * (W/nf + 0.18u)' nrd='0.18u / W' nrs='0.18u / W' sa=0 sb=0 sd=0
VR_m574 nref m574r 0
XO_m574 m574o m574r Vdd Vdd pfet_03v3 L=0.889u W=2.698u nf=1 ad='int((nf+1)/2) * W/nf * 0.18u' as='int((nf+2)/2) * W/nf * 0.18u' pd='2*int((nf+1)/2) * (W/nf + 0.18u)' ps='2*int((nf+2)/2) * (W/nf + 0.18u)' nrd='0.18u / W' nrs='0.18u / W' sa=0 sb=0 sd=0
VO_m574 m574o Vmem 0
XR_m575 m575r m575r Vdd Vdd pfet_03v3 L=1.841u W=1.188u nf=1 ad='int((nf+1)/2) * W/nf * 0.18u' as='int((nf+2)/2) * W/nf * 0.18u' pd='2*int((nf+1)/2) * (W/nf + 0.18u)' ps='2*int((nf+2)/2) * (W/nf + 0.18u)' nrd='0.18u / W' nrs='0.18u / W' sa=0 sb=0 sd=0
VR_m575 nref m575r 0
XO_m575 m575o m575r Vdd Vdd pfet_03v3 L=0.346u W=0.223u nf=1 ad='int((nf+1)/2) * W/nf * 0.18u' as='int((nf+2)/2) * W/nf * 0.18u' pd='2*int((nf+1)/2) * (W/nf + 0.18u)' ps='2*int((nf+2)/2) * (W/nf + 0.18u)' nrd='0.18u / W' nrs='0.18u / W' sa=0 sb=0 sd=0
VO_m575 m575o Vmem 0
XR_m576 m576r m576r Vdd Vdd pfet_03v3 L=0.68u W=0.477u nf=1 ad='int((nf+1)/2) * W/nf * 0.18u' as='int((nf+2)/2) * W/nf * 0.18u' pd='2*int((nf+1)/2) * (W/nf + 0.18u)' ps='2*int((nf+2)/2) * (W/nf + 0.18u)' nrd='0.18u / W' nrs='0.18u / W' sa=0 sb=0 sd=0
VR_m576 nref m576r 0
XO_m576 m576o m576r Vdd Vdd pfet_03v3 L=4.612u W=0.343u nf=1 ad='int((nf+1)/2) * W/nf * 0.18u' as='int((nf+2)/2) * W/nf * 0.18u' pd='2*int((nf+1)/2) * (W/nf + 0.18u)' ps='2*int((nf+2)/2) * (W/nf + 0.18u)' nrd='0.18u / W' nrs='0.18u / W' sa=0 sb=0 sd=0
VO_m576 m576o Vmem 0
XR_m577 m577r m577r Vdd Vdd pfet_03v3 L=1.764u W=1.345u nf=1 ad='int((nf+1)/2) * W/nf * 0.18u' as='int((nf+2)/2) * W/nf * 0.18u' pd='2*int((nf+1)/2) * (W/nf + 0.18u)' ps='2*int((nf+2)/2) * (W/nf + 0.18u)' nrd='0.18u / W' nrs='0.18u / W' sa=0 sb=0 sd=0
VR_m577 nref m577r 0
XO_m577 m577o m577r Vdd Vdd pfet_03v3 L=7.368u W=0.516u nf=1 ad='int((nf+1)/2) * W/nf * 0.18u' as='int((nf+2)/2) * W/nf * 0.18u' pd='2*int((nf+1)/2) * (W/nf + 0.18u)' ps='2*int((nf+2)/2) * (W/nf + 0.18u)' nrd='0.18u / W' nrs='0.18u / W' sa=0 sb=0 sd=0
VO_m577 m577o Vmem 0
XR_m578 m578r m578r Vdd Vdd pfet_03v3 L=0.318u W=0.325u nf=1 ad='int((nf+1)/2) * W/nf * 0.18u' as='int((nf+2)/2) * W/nf * 0.18u' pd='2*int((nf+1)/2) * (W/nf + 0.18u)' ps='2*int((nf+2)/2) * (W/nf + 0.18u)' nrd='0.18u / W' nrs='0.18u / W' sa=0 sb=0 sd=0
VR_m578 nref m578r 0
XO_m578 m578o m578r Vdd Vdd pfet_03v3 L=3.414u W=1.483u nf=1 ad='int((nf+1)/2) * W/nf * 0.18u' as='int((nf+2)/2) * W/nf * 0.18u' pd='2*int((nf+1)/2) * (W/nf + 0.18u)' ps='2*int((nf+2)/2) * (W/nf + 0.18u)' nrd='0.18u / W' nrs='0.18u / W' sa=0 sb=0 sd=0
VO_m578 m578o Vmem 0
XR_m579 m579r m579r Vdd Vdd pfet_03v3 L=2.908u W=0.546u nf=1 ad='int((nf+1)/2) * W/nf * 0.18u' as='int((nf+2)/2) * W/nf * 0.18u' pd='2*int((nf+1)/2) * (W/nf + 0.18u)' ps='2*int((nf+2)/2) * (W/nf + 0.18u)' nrd='0.18u / W' nrs='0.18u / W' sa=0 sb=0 sd=0
VR_m579 nref m579r 0
XO_m579 m579o m579r Vdd Vdd pfet_03v3 L=2.435u W=1.487u nf=1 ad='int((nf+1)/2) * W/nf * 0.18u' as='int((nf+2)/2) * W/nf * 0.18u' pd='2*int((nf+1)/2) * (W/nf + 0.18u)' ps='2*int((nf+2)/2) * (W/nf + 0.18u)' nrd='0.18u / W' nrs='0.18u / W' sa=0 sb=0 sd=0
VO_m579 m579o Vmem 0
XR_m580 m580r m580r Vdd Vdd pfet_03v3 L=1.418u W=0.375u nf=1 ad='int((nf+1)/2) * W/nf * 0.18u' as='int((nf+2)/2) * W/nf * 0.18u' pd='2*int((nf+1)/2) * (W/nf + 0.18u)' ps='2*int((nf+2)/2) * (W/nf + 0.18u)' nrd='0.18u / W' nrs='0.18u / W' sa=0 sb=0 sd=0
VR_m580 nref m580r 0
XO_m580 m580o m580r Vdd Vdd pfet_03v3 L=0.514u W=0.424u nf=1 ad='int((nf+1)/2) * W/nf * 0.18u' as='int((nf+2)/2) * W/nf * 0.18u' pd='2*int((nf+1)/2) * (W/nf + 0.18u)' ps='2*int((nf+2)/2) * (W/nf + 0.18u)' nrd='0.18u / W' nrs='0.18u / W' sa=0 sb=0 sd=0
VO_m580 m580o Vmem 0
XR_m581 m581r m581r Vdd Vdd pfet_03v3 L=1.097u W=2.085u nf=1 ad='int((nf+1)/2) * W/nf * 0.18u' as='int((nf+2)/2) * W/nf * 0.18u' pd='2*int((nf+1)/2) * (W/nf + 0.18u)' ps='2*int((nf+2)/2) * (W/nf + 0.18u)' nrd='0.18u / W' nrs='0.18u / W' sa=0 sb=0 sd=0
VR_m581 nref m581r 0
XO_m581 m581o m581r Vdd Vdd pfet_03v3 L=6.97u W=1.452u nf=1 ad='int((nf+1)/2) * W/nf * 0.18u' as='int((nf+2)/2) * W/nf * 0.18u' pd='2*int((nf+1)/2) * (W/nf + 0.18u)' ps='2*int((nf+2)/2) * (W/nf + 0.18u)' nrd='0.18u / W' nrs='0.18u / W' sa=0 sb=0 sd=0
VO_m581 m581o Vmem 0
XR_m582 m582r m582r Vdd Vdd pfet_03v3 L=0.316u W=0.516u nf=1 ad='int((nf+1)/2) * W/nf * 0.18u' as='int((nf+2)/2) * W/nf * 0.18u' pd='2*int((nf+1)/2) * (W/nf + 0.18u)' ps='2*int((nf+2)/2) * (W/nf + 0.18u)' nrd='0.18u / W' nrs='0.18u / W' sa=0 sb=0 sd=0
VR_m582 nref m582r 0
XO_m582 m582o m582r Vdd Vdd pfet_03v3 L=0.325u W=0.703u nf=1 ad='int((nf+1)/2) * W/nf * 0.18u' as='int((nf+2)/2) * W/nf * 0.18u' pd='2*int((nf+1)/2) * (W/nf + 0.18u)' ps='2*int((nf+2)/2) * (W/nf + 0.18u)' nrd='0.18u / W' nrs='0.18u / W' sa=0 sb=0 sd=0
VO_m582 m582o Vmem 0
XR_m583 m583r m583r Vdd Vdd pfet_03v3 L=0.47u W=3.661u nf=1 ad='int((nf+1)/2) * W/nf * 0.18u' as='int((nf+2)/2) * W/nf * 0.18u' pd='2*int((nf+1)/2) * (W/nf + 0.18u)' ps='2*int((nf+2)/2) * (W/nf + 0.18u)' nrd='0.18u / W' nrs='0.18u / W' sa=0 sb=0 sd=0
VR_m583 nref m583r 0
XO_m583 m583o m583r Vdd Vdd pfet_03v3 L=1.259u W=1.556u nf=1 ad='int((nf+1)/2) * W/nf * 0.18u' as='int((nf+2)/2) * W/nf * 0.18u' pd='2*int((nf+1)/2) * (W/nf + 0.18u)' ps='2*int((nf+2)/2) * (W/nf + 0.18u)' nrd='0.18u / W' nrs='0.18u / W' sa=0 sb=0 sd=0
VO_m583 m583o Vmem 0
XR_m584 m584r m584r Vdd Vdd pfet_03v3 L=0.408u W=0.856u nf=1 ad='int((nf+1)/2) * W/nf * 0.18u' as='int((nf+2)/2) * W/nf * 0.18u' pd='2*int((nf+1)/2) * (W/nf + 0.18u)' ps='2*int((nf+2)/2) * (W/nf + 0.18u)' nrd='0.18u / W' nrs='0.18u / W' sa=0 sb=0 sd=0
VR_m584 nref m584r 0
XO_m584 m584o m584r Vdd Vdd pfet_03v3 L=0.336u W=0.859u nf=1 ad='int((nf+1)/2) * W/nf * 0.18u' as='int((nf+2)/2) * W/nf * 0.18u' pd='2*int((nf+1)/2) * (W/nf + 0.18u)' ps='2*int((nf+2)/2) * (W/nf + 0.18u)' nrd='0.18u / W' nrs='0.18u / W' sa=0 sb=0 sd=0
VO_m584 m584o Vmem 0
XR_m585 m585r m585r Vdd Vdd pfet_03v3 L=1.455u W=0.791u nf=1 ad='int((nf+1)/2) * W/nf * 0.18u' as='int((nf+2)/2) * W/nf * 0.18u' pd='2*int((nf+1)/2) * (W/nf + 0.18u)' ps='2*int((nf+2)/2) * (W/nf + 0.18u)' nrd='0.18u / W' nrs='0.18u / W' sa=0 sb=0 sd=0
VR_m585 nref m585r 0
XO_m585 m585o m585r Vdd Vdd pfet_03v3 L=1.646u W=1.142u nf=1 ad='int((nf+1)/2) * W/nf * 0.18u' as='int((nf+2)/2) * W/nf * 0.18u' pd='2*int((nf+1)/2) * (W/nf + 0.18u)' ps='2*int((nf+2)/2) * (W/nf + 0.18u)' nrd='0.18u / W' nrs='0.18u / W' sa=0 sb=0 sd=0
VO_m585 m585o Vmem 0
XR_m586 m586r m586r Vdd Vdd pfet_03v3 L=1.08u W=0.525u nf=1 ad='int((nf+1)/2) * W/nf * 0.18u' as='int((nf+2)/2) * W/nf * 0.18u' pd='2*int((nf+1)/2) * (W/nf + 0.18u)' ps='2*int((nf+2)/2) * (W/nf + 0.18u)' nrd='0.18u / W' nrs='0.18u / W' sa=0 sb=0 sd=0
VR_m586 nref m586r 0
XO_m586 m586o m586r Vdd Vdd pfet_03v3 L=1.781u W=0.832u nf=1 ad='int((nf+1)/2) * W/nf * 0.18u' as='int((nf+2)/2) * W/nf * 0.18u' pd='2*int((nf+1)/2) * (W/nf + 0.18u)' ps='2*int((nf+2)/2) * (W/nf + 0.18u)' nrd='0.18u / W' nrs='0.18u / W' sa=0 sb=0 sd=0
VO_m586 m586o Vmem 0
XR_m587 m587r m587r Vdd Vdd pfet_03v3 L=1.613u W=1.224u nf=1 ad='int((nf+1)/2) * W/nf * 0.18u' as='int((nf+2)/2) * W/nf * 0.18u' pd='2*int((nf+1)/2) * (W/nf + 0.18u)' ps='2*int((nf+2)/2) * (W/nf + 0.18u)' nrd='0.18u / W' nrs='0.18u / W' sa=0 sb=0 sd=0
VR_m587 nref m587r 0
XO_m587 m587o m587r Vdd Vdd pfet_03v3 L=0.646u W=1.322u nf=1 ad='int((nf+1)/2) * W/nf * 0.18u' as='int((nf+2)/2) * W/nf * 0.18u' pd='2*int((nf+1)/2) * (W/nf + 0.18u)' ps='2*int((nf+2)/2) * (W/nf + 0.18u)' nrd='0.18u / W' nrs='0.18u / W' sa=0 sb=0 sd=0
VO_m587 m587o Vmem 0
XR_m588 m588r m588r Vdd Vdd pfet_03v3 L=1.348u W=1.312u nf=1 ad='int((nf+1)/2) * W/nf * 0.18u' as='int((nf+2)/2) * W/nf * 0.18u' pd='2*int((nf+1)/2) * (W/nf + 0.18u)' ps='2*int((nf+2)/2) * (W/nf + 0.18u)' nrd='0.18u / W' nrs='0.18u / W' sa=0 sb=0 sd=0
VR_m588 nref m588r 0
XO_m588 m588o m588r Vdd Vdd pfet_03v3 L=6.673u W=1.389u nf=1 ad='int((nf+1)/2) * W/nf * 0.18u' as='int((nf+2)/2) * W/nf * 0.18u' pd='2*int((nf+1)/2) * (W/nf + 0.18u)' ps='2*int((nf+2)/2) * (W/nf + 0.18u)' nrd='0.18u / W' nrs='0.18u / W' sa=0 sb=0 sd=0
VO_m588 m588o Vmem 0
XR_m589 m589r m589r Vdd Vdd pfet_03v3 L=0.329u W=0.521u nf=1 ad='int((nf+1)/2) * W/nf * 0.18u' as='int((nf+2)/2) * W/nf * 0.18u' pd='2*int((nf+1)/2) * (W/nf + 0.18u)' ps='2*int((nf+2)/2) * (W/nf + 0.18u)' nrd='0.18u / W' nrs='0.18u / W' sa=0 sb=0 sd=0
VR_m589 nref m589r 0
XO_m589 m589o m589r Vdd Vdd pfet_03v3 L=1.81u W=3.373u nf=1 ad='int((nf+1)/2) * W/nf * 0.18u' as='int((nf+2)/2) * W/nf * 0.18u' pd='2*int((nf+1)/2) * (W/nf + 0.18u)' ps='2*int((nf+2)/2) * (W/nf + 0.18u)' nrd='0.18u / W' nrs='0.18u / W' sa=0 sb=0 sd=0
VO_m589 m589o Vmem 0
XR_m590 m590r m590r Vdd Vdd pfet_03v3 L=0.43u W=0.267u nf=1 ad='int((nf+1)/2) * W/nf * 0.18u' as='int((nf+2)/2) * W/nf * 0.18u' pd='2*int((nf+1)/2) * (W/nf + 0.18u)' ps='2*int((nf+2)/2) * (W/nf + 0.18u)' nrd='0.18u / W' nrs='0.18u / W' sa=0 sb=0 sd=0
VR_m590 nref m590r 0
XO_m590 m590o m590r Vdd Vdd pfet_03v3 L=0.631u W=3.322u nf=1 ad='int((nf+1)/2) * W/nf * 0.18u' as='int((nf+2)/2) * W/nf * 0.18u' pd='2*int((nf+1)/2) * (W/nf + 0.18u)' ps='2*int((nf+2)/2) * (W/nf + 0.18u)' nrd='0.18u / W' nrs='0.18u / W' sa=0 sb=0 sd=0
VO_m590 m590o Vmem 0
XR_m591 m591r m591r Vdd Vdd pfet_03v3 L=0.351u W=0.422u nf=1 ad='int((nf+1)/2) * W/nf * 0.18u' as='int((nf+2)/2) * W/nf * 0.18u' pd='2*int((nf+1)/2) * (W/nf + 0.18u)' ps='2*int((nf+2)/2) * (W/nf + 0.18u)' nrd='0.18u / W' nrs='0.18u / W' sa=0 sb=0 sd=0
VR_m591 nref m591r 0
XO_m591 m591o m591r Vdd Vdd pfet_03v3 L=0.348u W=0.572u nf=1 ad='int((nf+1)/2) * W/nf * 0.18u' as='int((nf+2)/2) * W/nf * 0.18u' pd='2*int((nf+1)/2) * (W/nf + 0.18u)' ps='2*int((nf+2)/2) * (W/nf + 0.18u)' nrd='0.18u / W' nrs='0.18u / W' sa=0 sb=0 sd=0
VO_m591 m591o Vmem 0
XR_m592 m592r m592r Vdd Vdd pfet_03v3 L=0.424u W=2.989u nf=1 ad='int((nf+1)/2) * W/nf * 0.18u' as='int((nf+2)/2) * W/nf * 0.18u' pd='2*int((nf+1)/2) * (W/nf + 0.18u)' ps='2*int((nf+2)/2) * (W/nf + 0.18u)' nrd='0.18u / W' nrs='0.18u / W' sa=0 sb=0 sd=0
VR_m592 nref m592r 0
XO_m592 m592o m592r Vdd Vdd pfet_03v3 L=6.943u W=0.975u nf=1 ad='int((nf+1)/2) * W/nf * 0.18u' as='int((nf+2)/2) * W/nf * 0.18u' pd='2*int((nf+1)/2) * (W/nf + 0.18u)' ps='2*int((nf+2)/2) * (W/nf + 0.18u)' nrd='0.18u / W' nrs='0.18u / W' sa=0 sb=0 sd=0
VO_m592 m592o Vmem 0
XR_m593 m593r m593r Vdd Vdd pfet_03v3 L=2.93u W=1.457u nf=1 ad='int((nf+1)/2) * W/nf * 0.18u' as='int((nf+2)/2) * W/nf * 0.18u' pd='2*int((nf+1)/2) * (W/nf + 0.18u)' ps='2*int((nf+2)/2) * (W/nf + 0.18u)' nrd='0.18u / W' nrs='0.18u / W' sa=0 sb=0 sd=0
VR_m593 nref m593r 0
XO_m593 m593o m593r Vdd Vdd pfet_03v3 L=2.615u W=2.897u nf=1 ad='int((nf+1)/2) * W/nf * 0.18u' as='int((nf+2)/2) * W/nf * 0.18u' pd='2*int((nf+1)/2) * (W/nf + 0.18u)' ps='2*int((nf+2)/2) * (W/nf + 0.18u)' nrd='0.18u / W' nrs='0.18u / W' sa=0 sb=0 sd=0
VO_m593 m593o Vmem 0
XR_m594 m594r m594r Vdd Vdd pfet_03v3 L=1.352u W=3.857u nf=1 ad='int((nf+1)/2) * W/nf * 0.18u' as='int((nf+2)/2) * W/nf * 0.18u' pd='2*int((nf+1)/2) * (W/nf + 0.18u)' ps='2*int((nf+2)/2) * (W/nf + 0.18u)' nrd='0.18u / W' nrs='0.18u / W' sa=0 sb=0 sd=0
VR_m594 nref m594r 0
XO_m594 m594o m594r Vdd Vdd pfet_03v3 L=7.386u W=0.288u nf=1 ad='int((nf+1)/2) * W/nf * 0.18u' as='int((nf+2)/2) * W/nf * 0.18u' pd='2*int((nf+1)/2) * (W/nf + 0.18u)' ps='2*int((nf+2)/2) * (W/nf + 0.18u)' nrd='0.18u / W' nrs='0.18u / W' sa=0 sb=0 sd=0
VO_m594 m594o Vmem 0
XR_m595 m595r m595r Vdd Vdd pfet_03v3 L=0.74u W=0.482u nf=1 ad='int((nf+1)/2) * W/nf * 0.18u' as='int((nf+2)/2) * W/nf * 0.18u' pd='2*int((nf+1)/2) * (W/nf + 0.18u)' ps='2*int((nf+2)/2) * (W/nf + 0.18u)' nrd='0.18u / W' nrs='0.18u / W' sa=0 sb=0 sd=0
VR_m595 nref m595r 0
XO_m595 m595o m595r Vdd Vdd pfet_03v3 L=6.265u W=0.386u nf=1 ad='int((nf+1)/2) * W/nf * 0.18u' as='int((nf+2)/2) * W/nf * 0.18u' pd='2*int((nf+1)/2) * (W/nf + 0.18u)' ps='2*int((nf+2)/2) * (W/nf + 0.18u)' nrd='0.18u / W' nrs='0.18u / W' sa=0 sb=0 sd=0
VO_m595 m595o Vmem 0
XR_m596 m596r m596r Vdd Vdd pfet_03v3 L=0.631u W=1.668u nf=1 ad='int((nf+1)/2) * W/nf * 0.18u' as='int((nf+2)/2) * W/nf * 0.18u' pd='2*int((nf+1)/2) * (W/nf + 0.18u)' ps='2*int((nf+2)/2) * (W/nf + 0.18u)' nrd='0.18u / W' nrs='0.18u / W' sa=0 sb=0 sd=0
VR_m596 nref m596r 0
XO_m596 m596o m596r Vdd Vdd pfet_03v3 L=3.708u W=3.898u nf=1 ad='int((nf+1)/2) * W/nf * 0.18u' as='int((nf+2)/2) * W/nf * 0.18u' pd='2*int((nf+1)/2) * (W/nf + 0.18u)' ps='2*int((nf+2)/2) * (W/nf + 0.18u)' nrd='0.18u / W' nrs='0.18u / W' sa=0 sb=0 sd=0
VO_m596 m596o Vmem 0
XR_m597 m597r m597r Vdd Vdd pfet_03v3 L=3.633u W=2.323u nf=1 ad='int((nf+1)/2) * W/nf * 0.18u' as='int((nf+2)/2) * W/nf * 0.18u' pd='2*int((nf+1)/2) * (W/nf + 0.18u)' ps='2*int((nf+2)/2) * (W/nf + 0.18u)' nrd='0.18u / W' nrs='0.18u / W' sa=0 sb=0 sd=0
VR_m597 nref m597r 0
XO_m597 m597o m597r Vdd Vdd pfet_03v3 L=6.963u W=1.276u nf=1 ad='int((nf+1)/2) * W/nf * 0.18u' as='int((nf+2)/2) * W/nf * 0.18u' pd='2*int((nf+1)/2) * (W/nf + 0.18u)' ps='2*int((nf+2)/2) * (W/nf + 0.18u)' nrd='0.18u / W' nrs='0.18u / W' sa=0 sb=0 sd=0
VO_m597 m597o Vmem 0
XR_m598 m598r m598r Vdd Vdd pfet_03v3 L=0.622u W=0.726u nf=1 ad='int((nf+1)/2) * W/nf * 0.18u' as='int((nf+2)/2) * W/nf * 0.18u' pd='2*int((nf+1)/2) * (W/nf + 0.18u)' ps='2*int((nf+2)/2) * (W/nf + 0.18u)' nrd='0.18u / W' nrs='0.18u / W' sa=0 sb=0 sd=0
VR_m598 nref m598r 0
XO_m598 m598o m598r Vdd Vdd pfet_03v3 L=0.724u W=3.29u nf=1 ad='int((nf+1)/2) * W/nf * 0.18u' as='int((nf+2)/2) * W/nf * 0.18u' pd='2*int((nf+1)/2) * (W/nf + 0.18u)' ps='2*int((nf+2)/2) * (W/nf + 0.18u)' nrd='0.18u / W' nrs='0.18u / W' sa=0 sb=0 sd=0
VO_m598 m598o Vmem 0
XR_m599 m599r m599r Vdd Vdd pfet_03v3 L=2.797u W=1.054u nf=1 ad='int((nf+1)/2) * W/nf * 0.18u' as='int((nf+2)/2) * W/nf * 0.18u' pd='2*int((nf+1)/2) * (W/nf + 0.18u)' ps='2*int((nf+2)/2) * (W/nf + 0.18u)' nrd='0.18u / W' nrs='0.18u / W' sa=0 sb=0 sd=0
VR_m599 nref m599r 0
XO_m599 m599o m599r Vdd Vdd pfet_03v3 L=0.372u W=0.495u nf=1 ad='int((nf+1)/2) * W/nf * 0.18u' as='int((nf+2)/2) * W/nf * 0.18u' pd='2*int((nf+1)/2) * (W/nf + 0.18u)' ps='2*int((nf+2)/2) * (W/nf + 0.18u)' nrd='0.18u / W' nrs='0.18u / W' sa=0 sb=0 sd=0
VO_m599 m599o Vmem 0
.control
dc IREF 10n 30u 50n
wrdata esp.dat i(vr_m0) i(vo_m0) v(m0r) i(vr_m1) i(vo_m1) v(m1r) i(vr_m2) i(vo_m2) v(m2r) i(vr_m3) i(vo_m3) v(m3r) i(vr_m4) i(vo_m4) v(m4r) i(vr_m5) i(vo_m5) v(m5r) i(vr_m6) i(vo_m6) v(m6r) i(vr_m7) i(vo_m7) v(m7r) i(vr_m8) i(vo_m8) v(m8r) i(vr_m9) i(vo_m9) v(m9r) i(vr_m10) i(vo_m10) v(m10r) i(vr_m11) i(vo_m11) v(m11r) i(vr_m12) i(vo_m12) v(m12r) i(vr_m13) i(vo_m13) v(m13r) i(vr_m14) i(vo_m14) v(m14r) i(vr_m15) i(vo_m15) v(m15r) i(vr_m16) i(vo_m16) v(m16r) i(vr_m17) i(vo_m17) v(m17r) i(vr_m18) i(vo_m18) v(m18r) i(vr_m19) i(vo_m19) v(m19r) i(vr_m20) i(vo_m20) v(m20r) i(vr_m21) i(vo_m21) v(m21r) i(vr_m22) i(vo_m22) v(m22r) i(vr_m23) i(vo_m23) v(m23r) i(vr_m24) i(vo_m24) v(m24r) i(vr_m25) i(vo_m25) v(m25r) i(vr_m26) i(vo_m26) v(m26r) i(vr_m27) i(vo_m27) v(m27r) i(vr_m28) i(vo_m28) v(m28r) i(vr_m29) i(vo_m29) v(m29r) i(vr_m30) i(vo_m30) v(m30r) i(vr_m31) i(vo_m31) v(m31r) i(vr_m32) i(vo_m32) v(m32r) i(vr_m33) i(vo_m33) v(m33r) i(vr_m34) i(vo_m34) v(m34r) i(vr_m35) i(vo_m35) v(m35r) i(vr_m36) i(vo_m36) v(m36r) i(vr_m37) i(vo_m37) v(m37r) i(vr_m38) i(vo_m38) v(m38r) i(vr_m39) i(vo_m39) v(m39r) i(vr_m40) i(vo_m40) v(m40r) i(vr_m41) i(vo_m41) v(m41r) i(vr_m42) i(vo_m42) v(m42r) i(vr_m43) i(vo_m43) v(m43r) i(vr_m44) i(vo_m44) v(m44r) i(vr_m45) i(vo_m45) v(m45r) i(vr_m46) i(vo_m46) v(m46r) i(vr_m47) i(vo_m47) v(m47r) i(vr_m48) i(vo_m48) v(m48r) i(vr_m49) i(vo_m49) v(m49r) i(vr_m50) i(vo_m50) v(m50r) i(vr_m51) i(vo_m51) v(m51r) i(vr_m52) i(vo_m52) v(m52r) i(vr_m53) i(vo_m53) v(m53r) i(vr_m54) i(vo_m54) v(m54r) i(vr_m55) i(vo_m55) v(m55r) i(vr_m56) i(vo_m56) v(m56r) i(vr_m57) i(vo_m57) v(m57r) i(vr_m58) i(vo_m58) v(m58r) i(vr_m59) i(vo_m59) v(m59r) i(vr_m60) i(vo_m60) v(m60r) i(vr_m61) i(vo_m61) v(m61r) i(vr_m62) i(vo_m62) v(m62r) i(vr_m63) i(vo_m63) v(m63r) i(vr_m64) i(vo_m64) v(m64r) i(vr_m65) i(vo_m65) v(m65r) i(vr_m66) i(vo_m66) v(m66r) i(vr_m67) i(vo_m67) v(m67r) i(vr_m68) i(vo_m68) v(m68r) i(vr_m69) i(vo_m69) v(m69r) i(vr_m70) i(vo_m70) v(m70r) i(vr_m71) i(vo_m71) v(m71r) i(vr_m72) i(vo_m72) v(m72r) i(vr_m73) i(vo_m73) v(m73r) i(vr_m74) i(vo_m74) v(m74r) i(vr_m75) i(vo_m75) v(m75r) i(vr_m76) i(vo_m76) v(m76r) i(vr_m77) i(vo_m77) v(m77r) i(vr_m78) i(vo_m78) v(m78r) i(vr_m79) i(vo_m79) v(m79r) i(vr_m80) i(vo_m80) v(m80r) i(vr_m81) i(vo_m81) v(m81r) i(vr_m82) i(vo_m82) v(m82r) i(vr_m83) i(vo_m83) v(m83r) i(vr_m84) i(vo_m84) v(m84r) i(vr_m85) i(vo_m85) v(m85r) i(vr_m86) i(vo_m86) v(m86r) i(vr_m87) i(vo_m87) v(m87r) i(vr_m88) i(vo_m88) v(m88r) i(vr_m89) i(vo_m89) v(m89r) i(vr_m90) i(vo_m90) v(m90r) i(vr_m91) i(vo_m91) v(m91r) i(vr_m92) i(vo_m92) v(m92r) i(vr_m93) i(vo_m93) v(m93r) i(vr_m94) i(vo_m94) v(m94r) i(vr_m95) i(vo_m95) v(m95r) i(vr_m96) i(vo_m96) v(m96r) i(vr_m97) i(vo_m97) v(m97r) i(vr_m98) i(vo_m98) v(m98r) i(vr_m99) i(vo_m99) v(m99r) i(vr_m100) i(vo_m100) v(m100r) i(vr_m101) i(vo_m101) v(m101r) i(vr_m102) i(vo_m102) v(m102r) i(vr_m103) i(vo_m103) v(m103r) i(vr_m104) i(vo_m104) v(m104r) i(vr_m105) i(vo_m105) v(m105r) i(vr_m106) i(vo_m106) v(m106r) i(vr_m107) i(vo_m107) v(m107r) i(vr_m108) i(vo_m108) v(m108r) i(vr_m109) i(vo_m109) v(m109r) i(vr_m110) i(vo_m110) v(m110r) i(vr_m111) i(vo_m111) v(m111r) i(vr_m112) i(vo_m112) v(m112r) i(vr_m113) i(vo_m113) v(m113r) i(vr_m114) i(vo_m114) v(m114r) i(vr_m115) i(vo_m115) v(m115r) i(vr_m116) i(vo_m116) v(m116r) i(vr_m117) i(vo_m117) v(m117r) i(vr_m118) i(vo_m118) v(m118r) i(vr_m119) i(vo_m119) v(m119r) i(vr_m120) i(vo_m120) v(m120r) i(vr_m121) i(vo_m121) v(m121r) i(vr_m122) i(vo_m122) v(m122r) i(vr_m123) i(vo_m123) v(m123r) i(vr_m124) i(vo_m124) v(m124r) i(vr_m125) i(vo_m125) v(m125r) i(vr_m126) i(vo_m126) v(m126r) i(vr_m127) i(vo_m127) v(m127r) i(vr_m128) i(vo_m128) v(m128r) i(vr_m129) i(vo_m129) v(m129r) i(vr_m130) i(vo_m130) v(m130r) i(vr_m131) i(vo_m131) v(m131r) i(vr_m132) i(vo_m132) v(m132r) i(vr_m133) i(vo_m133) v(m133r) i(vr_m134) i(vo_m134) v(m134r) i(vr_m135) i(vo_m135) v(m135r) i(vr_m136) i(vo_m136) v(m136r) i(vr_m137) i(vo_m137) v(m137r) i(vr_m138) i(vo_m138) v(m138r) i(vr_m139) i(vo_m139) v(m139r) i(vr_m140) i(vo_m140) v(m140r) i(vr_m141) i(vo_m141) v(m141r) i(vr_m142) i(vo_m142) v(m142r) i(vr_m143) i(vo_m143) v(m143r) i(vr_m144) i(vo_m144) v(m144r) i(vr_m145) i(vo_m145) v(m145r) i(vr_m146) i(vo_m146) v(m146r) i(vr_m147) i(vo_m147) v(m147r) i(vr_m148) i(vo_m148) v(m148r) i(vr_m149) i(vo_m149) v(m149r) i(vr_m150) i(vo_m150) v(m150r) i(vr_m151) i(vo_m151) v(m151r) i(vr_m152) i(vo_m152) v(m152r) i(vr_m153) i(vo_m153) v(m153r) i(vr_m154) i(vo_m154) v(m154r) i(vr_m155) i(vo_m155) v(m155r) i(vr_m156) i(vo_m156) v(m156r) i(vr_m157) i(vo_m157) v(m157r) i(vr_m158) i(vo_m158) v(m158r) i(vr_m159) i(vo_m159) v(m159r) i(vr_m160) i(vo_m160) v(m160r) i(vr_m161) i(vo_m161) v(m161r) i(vr_m162) i(vo_m162) v(m162r) i(vr_m163) i(vo_m163) v(m163r) i(vr_m164) i(vo_m164) v(m164r) i(vr_m165) i(vo_m165) v(m165r) i(vr_m166) i(vo_m166) v(m166r) i(vr_m167) i(vo_m167) v(m167r) i(vr_m168) i(vo_m168) v(m168r) i(vr_m169) i(vo_m169) v(m169r) i(vr_m170) i(vo_m170) v(m170r) i(vr_m171) i(vo_m171) v(m171r) i(vr_m172) i(vo_m172) v(m172r) i(vr_m173) i(vo_m173) v(m173r) i(vr_m174) i(vo_m174) v(m174r) i(vr_m175) i(vo_m175) v(m175r) i(vr_m176) i(vo_m176) v(m176r) i(vr_m177) i(vo_m177) v(m177r) i(vr_m178) i(vo_m178) v(m178r) i(vr_m179) i(vo_m179) v(m179r) i(vr_m180) i(vo_m180) v(m180r) i(vr_m181) i(vo_m181) v(m181r) i(vr_m182) i(vo_m182) v(m182r) i(vr_m183) i(vo_m183) v(m183r) i(vr_m184) i(vo_m184) v(m184r) i(vr_m185) i(vo_m185) v(m185r) i(vr_m186) i(vo_m186) v(m186r) i(vr_m187) i(vo_m187) v(m187r) i(vr_m188) i(vo_m188) v(m188r) i(vr_m189) i(vo_m189) v(m189r) i(vr_m190) i(vo_m190) v(m190r) i(vr_m191) i(vo_m191) v(m191r) i(vr_m192) i(vo_m192) v(m192r) i(vr_m193) i(vo_m193) v(m193r) i(vr_m194) i(vo_m194) v(m194r) i(vr_m195) i(vo_m195) v(m195r) i(vr_m196) i(vo_m196) v(m196r) i(vr_m197) i(vo_m197) v(m197r) i(vr_m198) i(vo_m198) v(m198r) i(vr_m199) i(vo_m199) v(m199r) i(vr_m200) i(vo_m200) v(m200r) i(vr_m201) i(vo_m201) v(m201r) i(vr_m202) i(vo_m202) v(m202r) i(vr_m203) i(vo_m203) v(m203r) i(vr_m204) i(vo_m204) v(m204r) i(vr_m205) i(vo_m205) v(m205r) i(vr_m206) i(vo_m206) v(m206r) i(vr_m207) i(vo_m207) v(m207r) i(vr_m208) i(vo_m208) v(m208r) i(vr_m209) i(vo_m209) v(m209r) i(vr_m210) i(vo_m210) v(m210r) i(vr_m211) i(vo_m211) v(m211r) i(vr_m212) i(vo_m212) v(m212r) i(vr_m213) i(vo_m213) v(m213r) i(vr_m214) i(vo_m214) v(m214r) i(vr_m215) i(vo_m215) v(m215r) i(vr_m216) i(vo_m216) v(m216r) i(vr_m217) i(vo_m217) v(m217r) i(vr_m218) i(vo_m218) v(m218r) i(vr_m219) i(vo_m219) v(m219r) i(vr_m220) i(vo_m220) v(m220r) i(vr_m221) i(vo_m221) v(m221r) i(vr_m222) i(vo_m222) v(m222r) i(vr_m223) i(vo_m223) v(m223r) i(vr_m224) i(vo_m224) v(m224r) i(vr_m225) i(vo_m225) v(m225r) i(vr_m226) i(vo_m226) v(m226r) i(vr_m227) i(vo_m227) v(m227r) i(vr_m228) i(vo_m228) v(m228r) i(vr_m229) i(vo_m229) v(m229r) i(vr_m230) i(vo_m230) v(m230r) i(vr_m231) i(vo_m231) v(m231r) i(vr_m232) i(vo_m232) v(m232r) i(vr_m233) i(vo_m233) v(m233r) i(vr_m234) i(vo_m234) v(m234r) i(vr_m235) i(vo_m235) v(m235r) i(vr_m236) i(vo_m236) v(m236r) i(vr_m237) i(vo_m237) v(m237r) i(vr_m238) i(vo_m238) v(m238r) i(vr_m239) i(vo_m239) v(m239r) i(vr_m240) i(vo_m240) v(m240r) i(vr_m241) i(vo_m241) v(m241r) i(vr_m242) i(vo_m242) v(m242r) i(vr_m243) i(vo_m243) v(m243r) i(vr_m244) i(vo_m244) v(m244r) i(vr_m245) i(vo_m245) v(m245r) i(vr_m246) i(vo_m246) v(m246r) i(vr_m247) i(vo_m247) v(m247r) i(vr_m248) i(vo_m248) v(m248r) i(vr_m249) i(vo_m249) v(m249r) i(vr_m250) i(vo_m250) v(m250r) i(vr_m251) i(vo_m251) v(m251r) i(vr_m252) i(vo_m252) v(m252r) i(vr_m253) i(vo_m253) v(m253r) i(vr_m254) i(vo_m254) v(m254r) i(vr_m255) i(vo_m255) v(m255r) i(vr_m256) i(vo_m256) v(m256r) i(vr_m257) i(vo_m257) v(m257r) i(vr_m258) i(vo_m258) v(m258r) i(vr_m259) i(vo_m259) v(m259r) i(vr_m260) i(vo_m260) v(m260r) i(vr_m261) i(vo_m261) v(m261r) i(vr_m262) i(vo_m262) v(m262r) i(vr_m263) i(vo_m263) v(m263r) i(vr_m264) i(vo_m264) v(m264r) i(vr_m265) i(vo_m265) v(m265r) i(vr_m266) i(vo_m266) v(m266r) i(vr_m267) i(vo_m267) v(m267r) i(vr_m268) i(vo_m268) v(m268r) i(vr_m269) i(vo_m269) v(m269r) i(vr_m270) i(vo_m270) v(m270r) i(vr_m271) i(vo_m271) v(m271r) i(vr_m272) i(vo_m272) v(m272r) i(vr_m273) i(vo_m273) v(m273r) i(vr_m274) i(vo_m274) v(m274r) i(vr_m275) i(vo_m275) v(m275r) i(vr_m276) i(vo_m276) v(m276r) i(vr_m277) i(vo_m277) v(m277r) i(vr_m278) i(vo_m278) v(m278r) i(vr_m279) i(vo_m279) v(m279r) i(vr_m280) i(vo_m280) v(m280r) i(vr_m281) i(vo_m281) v(m281r) i(vr_m282) i(vo_m282) v(m282r) i(vr_m283) i(vo_m283) v(m283r) i(vr_m284) i(vo_m284) v(m284r) i(vr_m285) i(vo_m285) v(m285r) i(vr_m286) i(vo_m286) v(m286r) i(vr_m287) i(vo_m287) v(m287r) i(vr_m288) i(vo_m288) v(m288r) i(vr_m289) i(vo_m289) v(m289r) i(vr_m290) i(vo_m290) v(m290r) i(vr_m291) i(vo_m291) v(m291r) i(vr_m292) i(vo_m292) v(m292r) i(vr_m293) i(vo_m293) v(m293r) i(vr_m294) i(vo_m294) v(m294r) i(vr_m295) i(vo_m295) v(m295r) i(vr_m296) i(vo_m296) v(m296r) i(vr_m297) i(vo_m297) v(m297r) i(vr_m298) i(vo_m298) v(m298r) i(vr_m299) i(vo_m299) v(m299r) i(vr_m300) i(vo_m300) v(m300r) i(vr_m301) i(vo_m301) v(m301r) i(vr_m302) i(vo_m302) v(m302r) i(vr_m303) i(vo_m303) v(m303r) i(vr_m304) i(vo_m304) v(m304r) i(vr_m305) i(vo_m305) v(m305r) i(vr_m306) i(vo_m306) v(m306r) i(vr_m307) i(vo_m307) v(m307r) i(vr_m308) i(vo_m308) v(m308r) i(vr_m309) i(vo_m309) v(m309r) i(vr_m310) i(vo_m310) v(m310r) i(vr_m311) i(vo_m311) v(m311r) i(vr_m312) i(vo_m312) v(m312r) i(vr_m313) i(vo_m313) v(m313r) i(vr_m314) i(vo_m314) v(m314r) i(vr_m315) i(vo_m315) v(m315r) i(vr_m316) i(vo_m316) v(m316r) i(vr_m317) i(vo_m317) v(m317r) i(vr_m318) i(vo_m318) v(m318r) i(vr_m319) i(vo_m319) v(m319r) i(vr_m320) i(vo_m320) v(m320r) i(vr_m321) i(vo_m321) v(m321r) i(vr_m322) i(vo_m322) v(m322r) i(vr_m323) i(vo_m323) v(m323r) i(vr_m324) i(vo_m324) v(m324r) i(vr_m325) i(vo_m325) v(m325r) i(vr_m326) i(vo_m326) v(m326r) i(vr_m327) i(vo_m327) v(m327r) i(vr_m328) i(vo_m328) v(m328r) i(vr_m329) i(vo_m329) v(m329r) i(vr_m330) i(vo_m330) v(m330r) i(vr_m331) i(vo_m331) v(m331r) i(vr_m332) i(vo_m332) v(m332r) i(vr_m333) i(vo_m333) v(m333r) i(vr_m334) i(vo_m334) v(m334r) i(vr_m335) i(vo_m335) v(m335r) i(vr_m336) i(vo_m336) v(m336r) i(vr_m337) i(vo_m337) v(m337r) i(vr_m338) i(vo_m338) v(m338r) i(vr_m339) i(vo_m339) v(m339r) i(vr_m340) i(vo_m340) v(m340r) i(vr_m341) i(vo_m341) v(m341r) i(vr_m342) i(vo_m342) v(m342r) i(vr_m343) i(vo_m343) v(m343r) i(vr_m344) i(vo_m344) v(m344r) i(vr_m345) i(vo_m345) v(m345r) i(vr_m346) i(vo_m346) v(m346r) i(vr_m347) i(vo_m347) v(m347r) i(vr_m348) i(vo_m348) v(m348r) i(vr_m349) i(vo_m349) v(m349r) i(vr_m350) i(vo_m350) v(m350r) i(vr_m351) i(vo_m351) v(m351r) i(vr_m352) i(vo_m352) v(m352r) i(vr_m353) i(vo_m353) v(m353r) i(vr_m354) i(vo_m354) v(m354r) i(vr_m355) i(vo_m355) v(m355r) i(vr_m356) i(vo_m356) v(m356r) i(vr_m357) i(vo_m357) v(m357r) i(vr_m358) i(vo_m358) v(m358r) i(vr_m359) i(vo_m359) v(m359r) i(vr_m360) i(vo_m360) v(m360r) i(vr_m361) i(vo_m361) v(m361r) i(vr_m362) i(vo_m362) v(m362r) i(vr_m363) i(vo_m363) v(m363r) i(vr_m364) i(vo_m364) v(m364r) i(vr_m365) i(vo_m365) v(m365r) i(vr_m366) i(vo_m366) v(m366r) i(vr_m367) i(vo_m367) v(m367r) i(vr_m368) i(vo_m368) v(m368r) i(vr_m369) i(vo_m369) v(m369r) i(vr_m370) i(vo_m370) v(m370r) i(vr_m371) i(vo_m371) v(m371r) i(vr_m372) i(vo_m372) v(m372r) i(vr_m373) i(vo_m373) v(m373r) i(vr_m374) i(vo_m374) v(m374r) i(vr_m375) i(vo_m375) v(m375r) i(vr_m376) i(vo_m376) v(m376r) i(vr_m377) i(vo_m377) v(m377r) i(vr_m378) i(vo_m378) v(m378r) i(vr_m379) i(vo_m379) v(m379r) i(vr_m380) i(vo_m380) v(m380r) i(vr_m381) i(vo_m381) v(m381r) i(vr_m382) i(vo_m382) v(m382r) i(vr_m383) i(vo_m383) v(m383r) i(vr_m384) i(vo_m384) v(m384r) i(vr_m385) i(vo_m385) v(m385r) i(vr_m386) i(vo_m386) v(m386r) i(vr_m387) i(vo_m387) v(m387r) i(vr_m388) i(vo_m388) v(m388r) i(vr_m389) i(vo_m389) v(m389r) i(vr_m390) i(vo_m390) v(m390r) i(vr_m391) i(vo_m391) v(m391r) i(vr_m392) i(vo_m392) v(m392r) i(vr_m393) i(vo_m393) v(m393r) i(vr_m394) i(vo_m394) v(m394r) i(vr_m395) i(vo_m395) v(m395r) i(vr_m396) i(vo_m396) v(m396r) i(vr_m397) i(vo_m397) v(m397r) i(vr_m398) i(vo_m398) v(m398r) i(vr_m399) i(vo_m399) v(m399r) i(vr_m400) i(vo_m400) v(m400r) i(vr_m401) i(vo_m401) v(m401r) i(vr_m402) i(vo_m402) v(m402r) i(vr_m403) i(vo_m403) v(m403r) i(vr_m404) i(vo_m404) v(m404r) i(vr_m405) i(vo_m405) v(m405r) i(vr_m406) i(vo_m406) v(m406r) i(vr_m407) i(vo_m407) v(m407r) i(vr_m408) i(vo_m408) v(m408r) i(vr_m409) i(vo_m409) v(m409r) i(vr_m410) i(vo_m410) v(m410r) i(vr_m411) i(vo_m411) v(m411r) i(vr_m412) i(vo_m412) v(m412r) i(vr_m413) i(vo_m413) v(m413r) i(vr_m414) i(vo_m414) v(m414r) i(vr_m415) i(vo_m415) v(m415r) i(vr_m416) i(vo_m416) v(m416r) i(vr_m417) i(vo_m417) v(m417r) i(vr_m418) i(vo_m418) v(m418r) i(vr_m419) i(vo_m419) v(m419r) i(vr_m420) i(vo_m420) v(m420r) i(vr_m421) i(vo_m421) v(m421r) i(vr_m422) i(vo_m422) v(m422r) i(vr_m423) i(vo_m423) v(m423r) i(vr_m424) i(vo_m424) v(m424r) i(vr_m425) i(vo_m425) v(m425r) i(vr_m426) i(vo_m426) v(m426r) i(vr_m427) i(vo_m427) v(m427r) i(vr_m428) i(vo_m428) v(m428r) i(vr_m429) i(vo_m429) v(m429r) i(vr_m430) i(vo_m430) v(m430r) i(vr_m431) i(vo_m431) v(m431r) i(vr_m432) i(vo_m432) v(m432r) i(vr_m433) i(vo_m433) v(m433r) i(vr_m434) i(vo_m434) v(m434r) i(vr_m435) i(vo_m435) v(m435r) i(vr_m436) i(vo_m436) v(m436r) i(vr_m437) i(vo_m437) v(m437r) i(vr_m438) i(vo_m438) v(m438r) i(vr_m439) i(vo_m439) v(m439r) i(vr_m440) i(vo_m440) v(m440r) i(vr_m441) i(vo_m441) v(m441r) i(vr_m442) i(vo_m442) v(m442r) i(vr_m443) i(vo_m443) v(m443r) i(vr_m444) i(vo_m444) v(m444r) i(vr_m445) i(vo_m445) v(m445r) i(vr_m446) i(vo_m446) v(m446r) i(vr_m447) i(vo_m447) v(m447r) i(vr_m448) i(vo_m448) v(m448r) i(vr_m449) i(vo_m449) v(m449r) i(vr_m450) i(vo_m450) v(m450r) i(vr_m451) i(vo_m451) v(m451r) i(vr_m452) i(vo_m452) v(m452r) i(vr_m453) i(vo_m453) v(m453r) i(vr_m454) i(vo_m454) v(m454r) i(vr_m455) i(vo_m455) v(m455r) i(vr_m456) i(vo_m456) v(m456r) i(vr_m457) i(vo_m457) v(m457r) i(vr_m458) i(vo_m458) v(m458r) i(vr_m459) i(vo_m459) v(m459r) i(vr_m460) i(vo_m460) v(m460r) i(vr_m461) i(vo_m461) v(m461r) i(vr_m462) i(vo_m462) v(m462r) i(vr_m463) i(vo_m463) v(m463r) i(vr_m464) i(vo_m464) v(m464r) i(vr_m465) i(vo_m465) v(m465r) i(vr_m466) i(vo_m466) v(m466r) i(vr_m467) i(vo_m467) v(m467r) i(vr_m468) i(vo_m468) v(m468r) i(vr_m469) i(vo_m469) v(m469r) i(vr_m470) i(vo_m470) v(m470r) i(vr_m471) i(vo_m471) v(m471r) i(vr_m472) i(vo_m472) v(m472r) i(vr_m473) i(vo_m473) v(m473r) i(vr_m474) i(vo_m474) v(m474r) i(vr_m475) i(vo_m475) v(m475r) i(vr_m476) i(vo_m476) v(m476r) i(vr_m477) i(vo_m477) v(m477r) i(vr_m478) i(vo_m478) v(m478r) i(vr_m479) i(vo_m479) v(m479r) i(vr_m480) i(vo_m480) v(m480r) i(vr_m481) i(vo_m481) v(m481r) i(vr_m482) i(vo_m482) v(m482r) i(vr_m483) i(vo_m483) v(m483r) i(vr_m484) i(vo_m484) v(m484r) i(vr_m485) i(vo_m485) v(m485r) i(vr_m486) i(vo_m486) v(m486r) i(vr_m487) i(vo_m487) v(m487r) i(vr_m488) i(vo_m488) v(m488r) i(vr_m489) i(vo_m489) v(m489r) i(vr_m490) i(vo_m490) v(m490r) i(vr_m491) i(vo_m491) v(m491r) i(vr_m492) i(vo_m492) v(m492r) i(vr_m493) i(vo_m493) v(m493r) i(vr_m494) i(vo_m494) v(m494r) i(vr_m495) i(vo_m495) v(m495r) i(vr_m496) i(vo_m496) v(m496r) i(vr_m497) i(vo_m497) v(m497r) i(vr_m498) i(vo_m498) v(m498r) i(vr_m499) i(vo_m499) v(m499r) i(vr_m500) i(vo_m500) v(m500r) i(vr_m501) i(vo_m501) v(m501r) i(vr_m502) i(vo_m502) v(m502r) i(vr_m503) i(vo_m503) v(m503r) i(vr_m504) i(vo_m504) v(m504r) i(vr_m505) i(vo_m505) v(m505r) i(vr_m506) i(vo_m506) v(m506r) i(vr_m507) i(vo_m507) v(m507r) i(vr_m508) i(vo_m508) v(m508r) i(vr_m509) i(vo_m509) v(m509r) i(vr_m510) i(vo_m510) v(m510r) i(vr_m511) i(vo_m511) v(m511r) i(vr_m512) i(vo_m512) v(m512r) i(vr_m513) i(vo_m513) v(m513r) i(vr_m514) i(vo_m514) v(m514r) i(vr_m515) i(vo_m515) v(m515r) i(vr_m516) i(vo_m516) v(m516r) i(vr_m517) i(vo_m517) v(m517r) i(vr_m518) i(vo_m518) v(m518r) i(vr_m519) i(vo_m519) v(m519r) i(vr_m520) i(vo_m520) v(m520r) i(vr_m521) i(vo_m521) v(m521r) i(vr_m522) i(vo_m522) v(m522r) i(vr_m523) i(vo_m523) v(m523r) i(vr_m524) i(vo_m524) v(m524r) i(vr_m525) i(vo_m525) v(m525r) i(vr_m526) i(vo_m526) v(m526r) i(vr_m527) i(vo_m527) v(m527r) i(vr_m528) i(vo_m528) v(m528r) i(vr_m529) i(vo_m529) v(m529r) i(vr_m530) i(vo_m530) v(m530r) i(vr_m531) i(vo_m531) v(m531r) i(vr_m532) i(vo_m532) v(m532r) i(vr_m533) i(vo_m533) v(m533r) i(vr_m534) i(vo_m534) v(m534r) i(vr_m535) i(vo_m535) v(m535r) i(vr_m536) i(vo_m536) v(m536r) i(vr_m537) i(vo_m537) v(m537r) i(vr_m538) i(vo_m538) v(m538r) i(vr_m539) i(vo_m539) v(m539r) i(vr_m540) i(vo_m540) v(m540r) i(vr_m541) i(vo_m541) v(m541r) i(vr_m542) i(vo_m542) v(m542r) i(vr_m543) i(vo_m543) v(m543r) i(vr_m544) i(vo_m544) v(m544r) i(vr_m545) i(vo_m545) v(m545r) i(vr_m546) i(vo_m546) v(m546r) i(vr_m547) i(vo_m547) v(m547r) i(vr_m548) i(vo_m548) v(m548r) i(vr_m549) i(vo_m549) v(m549r) i(vr_m550) i(vo_m550) v(m550r) i(vr_m551) i(vo_m551) v(m551r) i(vr_m552) i(vo_m552) v(m552r) i(vr_m553) i(vo_m553) v(m553r) i(vr_m554) i(vo_m554) v(m554r) i(vr_m555) i(vo_m555) v(m555r) i(vr_m556) i(vo_m556) v(m556r) i(vr_m557) i(vo_m557) v(m557r) i(vr_m558) i(vo_m558) v(m558r) i(vr_m559) i(vo_m559) v(m559r) i(vr_m560) i(vo_m560) v(m560r) i(vr_m561) i(vo_m561) v(m561r) i(vr_m562) i(vo_m562) v(m562r) i(vr_m563) i(vo_m563) v(m563r) i(vr_m564) i(vo_m564) v(m564r) i(vr_m565) i(vo_m565) v(m565r) i(vr_m566) i(vo_m566) v(m566r) i(vr_m567) i(vo_m567) v(m567r) i(vr_m568) i(vo_m568) v(m568r) i(vr_m569) i(vo_m569) v(m569r) i(vr_m570) i(vo_m570) v(m570r) i(vr_m571) i(vo_m571) v(m571r) i(vr_m572) i(vo_m572) v(m572r) i(vr_m573) i(vo_m573) v(m573r) i(vr_m574) i(vo_m574) v(m574r) i(vr_m575) i(vo_m575) v(m575r) i(vr_m576) i(vo_m576) v(m576r) i(vr_m577) i(vo_m577) v(m577r) i(vr_m578) i(vo_m578) v(m578r) i(vr_m579) i(vo_m579) v(m579r) i(vr_m580) i(vo_m580) v(m580r) i(vr_m581) i(vo_m581) v(m581r) i(vr_m582) i(vo_m582) v(m582r) i(vr_m583) i(vo_m583) v(m583r) i(vr_m584) i(vo_m584) v(m584r) i(vr_m585) i(vo_m585) v(m585r) i(vr_m586) i(vo_m586) v(m586r) i(vr_m587) i(vo_m587) v(m587r) i(vr_m588) i(vo_m588) v(m588r) i(vr_m589) i(vo_m589) v(m589r) i(vr_m590) i(vo_m590) v(m590r) i(vr_m591) i(vo_m591) v(m591r) i(vr_m592) i(vo_m592) v(m592r) i(vr_m593) i(vo_m593) v(m593r) i(vr_m594) i(vo_m594) v(m594r) i(vr_m595) i(vo_m595) v(m595r) i(vr_m596) i(vo_m596) v(m596r) i(vr_m597) i(vo_m597) v(m597r) i(vr_m598) i(vo_m598) v(m598r) i(vr_m599) i(vo_m599) v(m599r)
.endc
.end
